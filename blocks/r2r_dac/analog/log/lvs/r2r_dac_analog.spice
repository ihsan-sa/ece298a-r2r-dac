* NGSPICE file created from r2r_dac_analog.ext - technology: gf180mcuD

.subckt r2r_dac_analog dac_code[7] dac_code[6] dac_code[5] dac_code[4] dac_code[3]
+ dac_code[2] dac_code[1] dac_code[0] vout vdd vss
X0 a_n132_14472# a_33552_2040# vss vss nfet_05v0 ad=0.2132p pd=1.34u as=0.2132p ps=1.34u w=0.82u l=0.6u
X1 a_33552_3988# dac_code[5] vdd vdd pfet_05v0 ad=0.3782p pd=1.84u as=0.3782p ps=1.84u w=1.22u l=0.5u
X2 a_n132_24072# a_33552_5176# vss vss nfet_05v0 ad=0.2132p pd=1.34u as=0.2132p ps=1.34u w=0.82u l=0.6u
X3 a_n132_24072# a_33552_5176# vdd vdd pfet_05v0 ad=0.3782p pd=1.84u as=0.3782p ps=1.84u w=1.22u l=0.5u
X4 vss a_33552_3988# a_n132_21672# vss nfet_05v0 ad=0.2132p pd=1.34u as=0.2132p ps=1.34u w=0.82u l=0.6u
X5 vss a_33552_852# a_n132_12072# vss nfet_05v0 ad=0.2132p pd=1.34u as=0.2132p ps=1.34u w=0.82u l=0.6u
X6 a_n132_16872# a_33552_2420# vdd vdd pfet_05v0 ad=0.3782p pd=1.84u as=0.3782p ps=1.84u w=1.22u l=0.5u
X7 vss a_33552_2420# a_n132_16872# vss nfet_05v0 ad=0.2132p pd=1.34u as=0.2132p ps=1.34u w=0.82u l=0.6u
X8 vdd a_33552_5176# a_n132_24072# vdd pfet_05v0 ad=0.3782p pd=1.84u as=0.3782p ps=1.84u w=1.22u l=0.5u
X9 a_n132_12072# a_33552_852# vss vss nfet_05v0 ad=0.2132p pd=1.34u as=0.2132p ps=1.34u w=0.82u l=0.6u
X10 a_n132_21672# a_33552_3988# vss vss nfet_05v0 ad=0.2132p pd=1.34u as=0.2132p ps=1.34u w=0.82u l=0.6u
X11 vss a_33552_2040# a_n132_14472# vss nfet_05v0 ad=0.2132p pd=1.34u as=0.2132p ps=1.34u w=0.82u l=0.6u
X12 vss a_33552_5176# a_n132_24072# vss nfet_05v0 ad=0.2132p pd=1.34u as=0.2132p ps=1.34u w=0.82u l=0.6u
X13 a_33552_5176# dac_code[6] vdd vdd pfet_05v0 ad=0.3782p pd=1.84u as=0.3782p ps=1.84u w=1.22u l=0.5u
X14 vdd dac_code[5] a_33552_3988# vdd pfet_05v0 ad=0.3782p pd=1.84u as=0.3782p ps=1.84u w=1.22u l=0.5u
X15 vdd a_33552_852# a_n132_12072# vdd pfet_05v0 ad=0.3782p pd=1.84u as=0.3782p ps=1.84u w=1.22u l=0.5u
X16 vss dac_code[3] a_33552_2420# vss nfet_05v0 ad=0.2132p pd=1.34u as=0.2132p ps=1.34u w=0.82u l=0.6u
X17 vss a_33552_852# a_n132_12072# vss nfet_05v0 ad=0.2132p pd=1.34u as=0.2132p ps=1.34u w=0.82u l=0.6u
X18 a_33552_3988# dac_code[5] vdd vdd pfet_05v0 ad=0.3782p pd=1.84u as=0.5368p ps=3.32u w=1.22u l=0.5u
X19 vss a_33552_3988# a_n132_21672# vss nfet_05v0 ad=0.2132p pd=1.34u as=0.2132p ps=1.34u w=0.82u l=0.6u
X20 vdd a_33552_3988# a_n132_21672# vdd pfet_05v0 ad=0.5368p pd=3.32u as=0.3782p ps=1.84u w=1.22u l=0.5u
X21 a_33552_472# dac_code[0] vss vss nfet_05v0 ad=0.2132p pd=1.34u as=0.2132p ps=1.34u w=0.82u l=0.6u
X22 vss a_33552_3608# a_n132_19272# vss nfet_05v0 ad=0.2132p pd=1.34u as=0.2132p ps=1.34u w=0.82u l=0.6u
X23 a_n132_24072# a_33552_5176# vss vss nfet_05v0 ad=0.2132p pd=1.34u as=0.2132p ps=1.34u w=0.82u l=0.6u
X24 vdd dac_code[6] a_33552_5176# vdd pfet_05v0 ad=0.3782p pd=1.84u as=0.3782p ps=1.84u w=1.22u l=0.5u
X25 a_n132_14472# a_33552_2040# vss vss nfet_05v0 ad=0.2132p pd=1.34u as=0.2132p ps=1.34u w=0.82u l=0.6u
X26 a_n132_21672# a_33552_3988# vss vss nfet_05v0 ad=0.2132p pd=1.34u as=0.2132p ps=1.34u w=0.82u l=0.6u
X27 a_n132_12072# a_33552_852# vss vss nfet_05v0 ad=0.2132p pd=1.34u as=0.2132p ps=1.34u w=0.82u l=0.6u
X28 a_33552_2420# dac_code[3] vss vss nfet_05v0 ad=0.2132p pd=1.34u as=0.2132p ps=1.34u w=0.82u l=0.6u
X29 a_n132_21672# a_33552_3988# vdd vdd pfet_05v0 ad=0.3782p pd=1.84u as=0.3782p ps=1.84u w=1.22u l=0.5u
X30 a_n132_8072# a_29672_8872# vss ppolyf_u r_width=2u r_length=0.14836m
X31 vss a_33552_5556# a_n132_26472# vss nfet_05v0 ad=0.2132p pd=1.34u as=0.2132p ps=1.34u w=0.82u l=0.6u
X32 a_n132_16872# a_33552_2420# vdd vdd pfet_05v0 ad=0.3782p pd=1.84u as=0.3782p ps=1.84u w=1.22u l=0.5u
X33 a_33552_3608# dac_code[4] vss vss nfet_05v0 ad=0.2132p pd=1.34u as=0.2132p ps=1.34u w=0.82u l=0.6u
X34 vss dac_code[2] a_33552_2040# vss nfet_05v0 ad=0.2132p pd=1.34u as=0.2132p ps=1.34u w=0.82u l=0.6u
X35 vdd dac_code[5] a_33552_3988# vdd pfet_05v0 ad=0.3782p pd=1.84u as=0.3782p ps=1.84u w=1.22u l=0.5u
X36 vss dac_code[6] a_33552_5176# vss nfet_05v0 ad=0.2132p pd=1.34u as=0.2132p ps=1.34u w=0.82u l=0.6u
X37 a_33552_5176# dac_code[6] vdd vdd pfet_05v0 ad=0.3782p pd=1.84u as=0.5368p ps=3.32u w=1.22u l=0.5u
X38 vdd a_33552_5176# a_n132_24072# vdd pfet_05v0 ad=0.5368p pd=3.32u as=0.3782p ps=1.84u w=1.22u l=0.5u
X39 a_n132_20072# a_29672_20872# vss ppolyf_u r_width=2u r_length=0.14836m
X40 vdd a_33552_2420# a_n132_16872# vdd pfet_05v0 ad=0.3782p pd=1.84u as=0.3782p ps=1.84u w=1.22u l=0.5u
X41 a_n132_16872# a_33552_2420# vss vss nfet_05v0 ad=0.2132p pd=1.34u as=0.2132p ps=1.34u w=0.82u l=0.6u
X42 vss a_33552_2040# a_n132_14472# vss nfet_05v0 ad=0.2132p pd=1.34u as=0.2132p ps=1.34u w=0.82u l=0.6u
X43 vdd a_33552_3988# a_n132_21672# vdd pfet_05v0 ad=0.3782p pd=1.84u as=0.3782p ps=1.84u w=1.22u l=0.5u
X44 vss a_33552_5176# a_n132_24072# vss nfet_05v0 ad=0.2132p pd=1.34u as=0.2132p ps=1.34u w=0.82u l=0.6u
X45 vss dac_code[7] a_33552_5556# vss nfet_05v0 ad=0.2132p pd=1.34u as=0.2132p ps=1.34u w=0.82u l=0.6u
X46 a_n132_24072# a_33552_5176# vdd vdd pfet_05v0 ad=0.3782p pd=1.84u as=0.3782p ps=1.84u w=1.22u l=0.5u
X47 vss dac_code[0] a_33552_472# vss nfet_05v0 ad=0.2132p pd=1.34u as=0.2132p ps=1.34u w=0.82u l=0.6u
X48 vdd dac_code[6] a_33552_5176# vdd pfet_05v0 ad=0.3782p pd=1.84u as=0.3782p ps=1.84u w=1.22u l=0.5u
X49 a_n132_14472# a_33552_2040# vss vss nfet_05v0 ad=0.2132p pd=1.34u as=0.2132p ps=1.34u w=0.82u l=0.6u
X50 a_n132_21672# a_33552_3988# vdd vdd pfet_05v0 ad=0.3782p pd=1.84u as=0.3782p ps=1.84u w=1.22u l=0.5u
X51 a_n132_24072# a_33552_5176# vss vss nfet_05v0 ad=0.2132p pd=1.34u as=0.2132p ps=1.34u w=0.82u l=0.6u
X52 a_n132_26472# a_29672_25672# vss ppolyf_u r_width=2u r_length=0.15m
X53 vss a_33552_2420# a_n132_16872# vss nfet_05v0 ad=0.2132p pd=1.34u as=0.2132p ps=1.34u w=0.82u l=0.6u
X54 a_n132_12072# a_33552_852# vdd vdd pfet_05v0 ad=0.3782p pd=1.84u as=0.3782p ps=1.84u w=1.22u l=0.5u
X55 a_n132_9672# a_33552_472# vdd vdd pfet_05v0 ad=0.3782p pd=1.84u as=0.3782p ps=1.84u w=1.22u l=0.5u
X56 a_33552_2420# dac_code[3] vss vss nfet_05v0 ad=0.2132p pd=1.34u as=0.2132p ps=1.34u w=0.82u l=0.6u
X57 a_n132_21672# a_33552_3988# vss vss nfet_05v0 ad=0.2132p pd=1.34u as=0.2132p ps=1.34u w=0.82u l=0.6u
X58 vdd a_33552_5176# a_n132_24072# vdd pfet_05v0 ad=0.3782p pd=1.84u as=0.3782p ps=1.84u w=1.22u l=0.5u
X59 a_n132_12072# a_33552_852# vss vss nfet_05v0 ad=0.2132p pd=1.34u as=0.2132p ps=1.34u w=0.82u l=0.6u
X60 vdd dac_code[5] a_33552_3988# vdd pfet_05v0 ad=0.3782p pd=1.84u as=0.3782p ps=1.84u w=1.22u l=0.5u
X61 a_33552_5556# dac_code[7] vss vss nfet_05v0 ad=0.2132p pd=1.34u as=0.2132p ps=1.34u w=0.82u l=0.6u
X62 a_n132_9672# a_33552_472# vss vss nfet_05v0 ad=0.2132p pd=1.34u as=0.2132p ps=1.34u w=0.82u l=0.6u
X63 vss a_33552_2040# a_n132_14472# vss nfet_05v0 ad=0.2132p pd=1.34u as=0.2132p ps=1.34u w=0.82u l=0.6u
X64 vss a_33552_5176# a_n132_24072# vss nfet_05v0 ad=0.2132p pd=1.34u as=0.2132p ps=1.34u w=0.82u l=0.6u
X65 a_n132_24072# a_33552_5176# vdd vdd pfet_05v0 ad=0.3782p pd=1.84u as=0.3782p ps=1.84u w=1.22u l=0.5u
X66 vss a_33552_852# a_n132_12072# vss nfet_05v0 ad=0.2132p pd=1.34u as=0.2132p ps=1.34u w=0.82u l=0.6u
X67 vss a_33552_3988# a_n132_21672# vss nfet_05v0 ad=0.2132p pd=1.34u as=0.2132p ps=1.34u w=0.82u l=0.6u
X68 vss dac_code[3] a_33552_2420# vss nfet_05v0 ad=0.2132p pd=1.34u as=0.2132p ps=1.34u w=0.82u l=0.6u
X69 a_n132_26472# a_33552_5556# vss vss nfet_05v0 ad=0.2132p pd=1.34u as=0.2132p ps=1.34u w=0.82u l=0.6u
X70 a_n132_24072# a_33552_5176# vss vss nfet_05v0 ad=0.2132p pd=1.34u as=0.2132p ps=1.34u w=0.82u l=0.6u
X71 a_n132_10472# a_n132_8072# vss ppolyf_u r_width=2u r_length=0.15m
X72 vdd dac_code[6] a_33552_5176# vdd pfet_05v0 ad=0.3782p pd=1.84u as=0.3782p ps=1.84u w=1.22u l=0.5u
X73 a_n132_14472# a_33552_2040# vss vss nfet_05v0 ad=0.2132p pd=1.34u as=0.2132p ps=1.34u w=0.82u l=0.6u
X74 a_33552_3988# dac_code[5] vdd vdd pfet_05v0 ad=0.3782p pd=1.84u as=0.3782p ps=1.84u w=1.22u l=0.5u
X75 vss a_33552_3608# a_n132_19272# vss nfet_05v0 ad=0.2132p pd=1.34u as=0.2132p ps=1.34u w=0.82u l=0.6u
X76 vdd a_33552_2040# a_n132_14472# vdd pfet_05v0 ad=0.3782p pd=1.84u as=0.3782p ps=1.84u w=1.22u l=0.5u
X77 a_33552_2420# dac_code[3] vss vss nfet_05v0 ad=0.2132p pd=1.34u as=0.3608p ps=2.52u w=0.82u l=0.6u
X78 vss a_33552_5556# a_n132_26472# vss nfet_05v0 ad=0.2132p pd=1.34u as=0.2132p ps=1.34u w=0.82u l=0.6u
X79 a_n132_9672# a_33552_472# vss vss nfet_05v0 ad=0.2132p pd=1.34u as=0.2132p ps=1.34u w=0.82u l=0.6u
X80 a_n132_16872# a_33552_2420# vdd vdd pfet_05v0 ad=0.3782p pd=1.84u as=0.3782p ps=1.84u w=1.22u l=0.5u
X81 vss a_33552_2420# a_n132_16872# vss nfet_05v0 ad=0.3608p pd=2.52u as=0.2132p ps=1.34u w=0.82u l=0.6u
X82 a_n132_15272# a_29672_16072# vss ppolyf_u r_width=2u r_length=0.14836m
X83 vdd dac_code[1] a_33552_852# vdd pfet_05v0 ad=0.3782p pd=1.84u as=0.3782p ps=1.84u w=1.22u l=0.5u
X84 a_n132_21672# a_33552_3988# vdd vdd pfet_05v0 ad=0.3782p pd=1.84u as=0.3782p ps=1.84u w=1.22u l=0.5u
X85 a_33552_5556# dac_code[7] vss vss nfet_05v0 ad=0.2132p pd=1.34u as=0.2132p ps=1.34u w=0.82u l=0.6u
X86 vdd dac_code[0] a_33552_472# vdd pfet_05v0 ad=0.3782p pd=1.84u as=0.3782p ps=1.84u w=1.22u l=0.5u
X87 a_33552_2040# dac_code[2] vdd vdd pfet_05v0 ad=0.3782p pd=1.84u as=0.3782p ps=1.84u w=1.22u l=0.5u
X88 a_33552_5176# dac_code[6] vdd vdd pfet_05v0 ad=0.3782p pd=1.84u as=0.3782p ps=1.84u w=1.22u l=0.5u
X89 vss dac_code[4] a_33552_3608# vss nfet_05v0 ad=0.2132p pd=1.34u as=0.2132p ps=1.34u w=0.82u l=0.6u
X90 a_n132_16872# a_33552_2420# vss vss nfet_05v0 ad=0.2132p pd=1.34u as=0.2132p ps=1.34u w=0.82u l=0.6u
X91 a_n132_12072# a_33552_852# vdd vdd pfet_05v0 ad=0.3782p pd=1.84u as=0.3782p ps=1.84u w=1.22u l=0.5u
X92 a_n132_9672# a_33552_472# vdd vdd pfet_05v0 ad=0.3782p pd=1.84u as=0.3782p ps=1.84u w=1.22u l=0.5u
X93 vdd a_33552_2420# a_n132_16872# vdd pfet_05v0 ad=0.3782p pd=1.84u as=0.3782p ps=1.84u w=1.22u l=0.5u
X94 vss dac_code[3] a_33552_2420# vss nfet_05v0 ad=0.2132p pd=1.34u as=0.2132p ps=1.34u w=0.82u l=0.6u
X95 a_n132_21672# a_33552_3988# vdd vdd pfet_05v0 ad=0.3782p pd=1.84u as=0.3782p ps=1.84u w=1.22u l=0.5u
X96 vss dac_code[7] a_33552_5556# vss nfet_05v0 ad=0.2132p pd=1.34u as=0.2132p ps=1.34u w=0.82u l=0.6u
X97 a_n132_24072# a_33552_5176# vdd vdd pfet_05v0 ad=0.3782p pd=1.84u as=0.3782p ps=1.84u w=1.22u l=0.5u
X98 a_n132_24072# a_33552_5176# vss vss nfet_05v0 ad=0.2132p pd=1.34u as=0.2132p ps=1.34u w=0.82u l=0.6u
X99 vss dac_code[0] a_33552_472# vss nfet_05v0 ad=0.2132p pd=1.34u as=0.2132p ps=1.34u w=0.82u l=0.6u
X100 a_n132_14472# a_33552_2040# vss vss nfet_05v0 ad=0.2132p pd=1.34u as=0.2132p ps=1.34u w=0.82u l=0.6u
X101 a_33552_3608# dac_code[4] vss vss nfet_05v0 ad=0.2132p pd=1.34u as=0.2132p ps=1.34u w=0.82u l=0.6u
X102 vss a_33552_2420# a_n132_16872# vss nfet_05v0 ad=0.2132p pd=1.34u as=0.2132p ps=1.34u w=0.82u l=0.6u
X103 a_n132_21672# a_33552_3988# vss vss nfet_05v0 ad=0.2132p pd=1.34u as=0.2132p ps=1.34u w=0.82u l=0.6u
X104 a_33552_5556# dac_code[7] vss vss nfet_05v0 ad=0.2132p pd=1.34u as=0.3608p ps=2.52u w=0.82u l=0.6u
X105 a_n132_12072# a_33552_852# vss vss nfet_05v0 ad=0.2132p pd=1.34u as=0.2132p ps=1.34u w=0.82u l=0.6u
X106 vss a_33552_5556# a_n132_26472# vss nfet_05v0 ad=0.3608p pd=2.52u as=0.2132p ps=1.34u w=0.82u l=0.6u
X107 a_n132_16872# a_33552_2420# vss vss nfet_05v0 ad=0.2132p pd=1.34u as=0.2132p ps=1.34u w=0.82u l=0.6u
X108 vdd a_33552_3608# a_n132_19272# vdd pfet_05v0 ad=0.3782p pd=1.84u as=0.3782p ps=1.84u w=1.22u l=0.5u
X109 vdd a_33552_472# a_n132_9672# vdd pfet_05v0 ad=0.5368p pd=3.32u as=0.3782p ps=1.84u w=1.22u l=0.5u
X110 vss a_33552_2040# a_n132_14472# vss nfet_05v0 ad=0.2132p pd=1.34u as=0.2132p ps=1.34u w=0.82u l=0.6u
X111 vdd a_33552_3988# a_n132_21672# vdd pfet_05v0 ad=0.3782p pd=1.84u as=0.3782p ps=1.84u w=1.22u l=0.5u
X112 vss a_33552_5176# a_n132_24072# vss nfet_05v0 ad=0.2132p pd=1.34u as=0.2132p ps=1.34u w=0.82u l=0.6u
X113 a_n132_24072# a_33552_5176# vdd vdd pfet_05v0 ad=0.3782p pd=1.84u as=0.3782p ps=1.84u w=1.22u l=0.5u
X114 a_n132_19272# a_33552_3608# vss vss nfet_05v0 ad=0.2132p pd=1.34u as=0.2132p ps=1.34u w=0.82u l=0.6u
X115 a_33552_852# dac_code[1] vdd vdd pfet_05v0 ad=0.3782p pd=1.84u as=0.5368p ps=3.32u w=1.22u l=0.5u
X116 a_33552_472# dac_code[0] vdd vdd pfet_05v0 ad=0.3782p pd=1.84u as=0.3782p ps=1.84u w=1.22u l=0.5u
X117 a_n132_9672# a_33552_472# vss vss nfet_05v0 ad=0.2132p pd=1.34u as=0.2132p ps=1.34u w=0.82u l=0.6u
X118 vss dac_code[3] a_33552_2420# vss nfet_05v0 ad=0.2132p pd=1.34u as=0.2132p ps=1.34u w=0.82u l=0.6u
X119 a_n132_26472# a_33552_5556# vss vss nfet_05v0 ad=0.2132p pd=1.34u as=0.2132p ps=1.34u w=0.82u l=0.6u
X120 a_33552_3608# dac_code[4] vdd vdd pfet_05v0 ad=0.3782p pd=1.84u as=0.3782p ps=1.84u w=1.22u l=0.5u
X121 vss a_33552_852# a_n132_12072# vss nfet_05v0 ad=0.2132p pd=1.34u as=0.2132p ps=1.34u w=0.82u l=0.6u
X122 vss a_33552_3988# a_n132_21672# vss nfet_05v0 ad=0.2132p pd=1.34u as=0.2132p ps=1.34u w=0.82u l=0.6u
X123 vss dac_code[7] a_33552_5556# vss nfet_05v0 ad=0.2132p pd=1.34u as=0.2132p ps=1.34u w=0.82u l=0.6u
X124 vdd a_33552_852# a_n132_12072# vdd pfet_05v0 ad=0.3782p pd=1.84u as=0.3782p ps=1.84u w=1.22u l=0.5u
X125 vss a_33552_3608# a_n132_19272# vss nfet_05v0 ad=0.2132p pd=1.34u as=0.2132p ps=1.34u w=0.82u l=0.6u
X126 vdd a_33552_5556# a_n132_26472# vdd pfet_05v0 ad=0.3782p pd=1.84u as=0.3782p ps=1.84u w=1.22u l=0.5u
X127 vdd a_33552_5176# a_n132_24072# vdd pfet_05v0 ad=0.3782p pd=1.84u as=0.3782p ps=1.84u w=1.22u l=0.5u
X128 vdd a_33552_472# a_n132_9672# vdd pfet_05v0 ad=0.3782p pd=1.84u as=0.3782p ps=1.84u w=1.22u l=0.5u
X129 a_n132_21672# a_33552_3988# vdd vdd pfet_05v0 ad=0.3782p pd=1.84u as=0.3782p ps=1.84u w=1.22u l=0.5u
X130 a_33552_3608# dac_code[4] vss vss nfet_05v0 ad=0.2132p pd=1.34u as=0.2132p ps=1.34u w=0.82u l=0.6u
X131 vdd a_33552_2040# a_n132_14472# vdd pfet_05v0 ad=0.3782p pd=1.84u as=0.3782p ps=1.84u w=1.22u l=0.5u
X132 a_33552_2420# dac_code[3] vss vss nfet_05v0 ad=0.2132p pd=1.34u as=0.2132p ps=1.34u w=0.82u l=0.6u
X133 vss a_33552_5556# a_n132_26472# vss nfet_05v0 ad=0.2132p pd=1.34u as=0.2132p ps=1.34u w=0.82u l=0.6u
X134 a_33552_5556# dac_code[7] vdd vdd pfet_05v0 ad=0.3782p pd=1.84u as=0.3782p ps=1.84u w=1.22u l=0.5u
X135 a_n132_22472# a_n132_20072# vss ppolyf_u r_width=2u r_length=0.15m
X136 vdd dac_code[5] a_33552_3988# vdd pfet_05v0 ad=0.3782p pd=1.84u as=0.3782p ps=1.84u w=1.22u l=0.5u
X137 vss dac_code[0] a_33552_472# vss nfet_05v0 ad=0.2132p pd=1.34u as=0.2132p ps=1.34u w=0.82u l=0.6u
X138 a_n132_26472# a_33552_5556# vss vss nfet_05v0 ad=0.2132p pd=1.34u as=0.2132p ps=1.34u w=0.82u l=0.6u
X139 a_n132_24072# a_33552_5176# vdd vdd pfet_05v0 ad=0.3782p pd=1.84u as=0.3782p ps=1.84u w=1.22u l=0.5u
X140 a_n132_12072# a_33552_852# vdd vdd pfet_05v0 ad=0.3782p pd=1.84u as=0.3782p ps=1.84u w=1.22u l=0.5u
X141 a_33552_472# dac_code[0] vdd vdd pfet_05v0 ad=0.3782p pd=1.84u as=0.3782p ps=1.84u w=1.22u l=0.5u
X142 a_n132_9672# a_33552_472# vdd vdd pfet_05v0 ad=0.3782p pd=1.84u as=0.3782p ps=1.84u w=1.22u l=0.5u
X143 vss dac_code[4] a_33552_3608# vss nfet_05v0 ad=0.2132p pd=1.34u as=0.2132p ps=1.34u w=0.82u l=0.6u
X144 vdd dac_code[2] a_33552_2040# vdd pfet_05v0 ad=0.3782p pd=1.84u as=0.3782p ps=1.84u w=1.22u l=0.5u
X145 a_n132_16872# a_33552_2420# vss vss nfet_05v0 ad=0.2132p pd=1.34u as=0.2132p ps=1.34u w=0.82u l=0.6u
X146 vdd a_33552_3988# a_n132_21672# vdd pfet_05v0 ad=0.3782p pd=1.84u as=0.3782p ps=1.84u w=1.22u l=0.5u
X147 vss dac_code[7] a_33552_5556# vss nfet_05v0 ad=0.2132p pd=1.34u as=0.2132p ps=1.34u w=0.82u l=0.6u
X148 a_n132_17672# a_n132_15272# vss ppolyf_u r_width=2u r_length=0.15m
X149 vdd dac_code[6] a_33552_5176# vdd pfet_05v0 ad=0.3782p pd=1.84u as=0.3782p ps=1.84u w=1.22u l=0.5u
X150 a_n132_24072# a_33552_5176# vss vss nfet_05v0 ad=0.2132p pd=1.34u as=0.2132p ps=1.34u w=0.82u l=0.6u
X151 a_n132_14472# a_33552_2040# vss vss nfet_05v0 ad=0.2132p pd=1.34u as=0.2132p ps=1.34u w=0.82u l=0.6u
X152 a_n132_21672# a_33552_3988# vdd vdd pfet_05v0 ad=0.3782p pd=1.84u as=0.3782p ps=1.84u w=1.22u l=0.5u
X153 a_33552_3608# dac_code[4] vss vss nfet_05v0 ad=0.2132p pd=1.34u as=0.3608p ps=2.52u w=0.82u l=0.6u
X154 vss a_33552_3608# a_n132_19272# vss nfet_05v0 ad=0.3608p pd=2.52u as=0.2132p ps=1.34u w=0.82u l=0.6u
X155 a_n132_12072# a_33552_852# vdd vdd pfet_05v0 ad=0.3782p pd=1.84u as=0.3782p ps=1.84u w=1.22u l=0.5u
X156 a_n132_9672# a_33552_472# vdd vdd pfet_05v0 ad=0.3782p pd=1.84u as=0.3782p ps=1.84u w=1.22u l=0.5u
X157 a_33552_2040# dac_code[2] vdd vdd pfet_05v0 ad=0.3782p pd=1.84u as=0.3782p ps=1.84u w=1.22u l=0.5u
X158 a_n132_16872# a_33552_2420# vss vss nfet_05v0 ad=0.2132p pd=1.34u as=0.2132p ps=1.34u w=0.82u l=0.6u
X159 a_33552_472# dac_code[0] vss vss nfet_05v0 ad=0.2132p pd=1.34u as=0.2132p ps=1.34u w=0.82u l=0.6u
X160 a_33552_5556# dac_code[7] vss vss nfet_05v0 ad=0.2132p pd=1.34u as=0.2132p ps=1.34u w=0.82u l=0.6u
X161 vdd a_33552_5176# a_n132_24072# vdd pfet_05v0 ad=0.3782p pd=1.84u as=0.3782p ps=1.84u w=1.22u l=0.5u
X162 a_n132_19272# a_33552_3608# vss vss nfet_05v0 ad=0.2132p pd=1.34u as=0.2132p ps=1.34u w=0.82u l=0.6u
X163 vdd a_33552_3608# a_n132_19272# vdd pfet_05v0 ad=0.3782p pd=1.84u as=0.3782p ps=1.84u w=1.22u l=0.5u
X164 vss a_33552_2040# a_n132_14472# vss nfet_05v0 ad=0.2132p pd=1.34u as=0.2132p ps=1.34u w=0.82u l=0.6u
X165 vdd a_33552_3988# a_n132_21672# vdd pfet_05v0 ad=0.3782p pd=1.84u as=0.3782p ps=1.84u w=1.22u l=0.5u
X166 vss a_33552_5176# a_n132_24072# vss nfet_05v0 ad=0.2132p pd=1.34u as=0.2132p ps=1.34u w=0.82u l=0.6u
X167 a_n132_24072# a_33552_5176# vdd vdd pfet_05v0 ad=0.3782p pd=1.84u as=0.3782p ps=1.84u w=1.22u l=0.5u
X168 vss dac_code[4] a_33552_3608# vss nfet_05v0 ad=0.2132p pd=1.34u as=0.2132p ps=1.34u w=0.82u l=0.6u
X169 a_n132_12072# a_29672_11272# vss ppolyf_u r_width=2u r_length=0.15m
X170 a_n132_14472# a_33552_2040# vdd vdd pfet_05v0 ad=0.3782p pd=1.84u as=0.3782p ps=1.84u w=1.22u l=0.5u
X171 a_n132_26472# a_33552_5556# vss vss nfet_05v0 ad=0.2132p pd=1.34u as=0.2132p ps=1.34u w=0.82u l=0.6u
X172 vdd a_33552_852# a_n132_12072# vdd pfet_05v0 ad=0.3782p pd=1.84u as=0.3782p ps=1.84u w=1.22u l=0.5u
X173 vss a_33552_2420# a_n132_16872# vss nfet_05v0 ad=0.2132p pd=1.34u as=0.2132p ps=1.34u w=0.82u l=0.6u
X174 vdd a_33552_472# a_n132_9672# vdd pfet_05v0 ad=0.3782p pd=1.84u as=0.3782p ps=1.84u w=1.22u l=0.5u
X175 a_n132_21672# a_33552_3988# vdd vdd pfet_05v0 ad=0.3782p pd=1.84u as=0.3782p ps=1.84u w=1.22u l=0.5u
X176 vdd a_33552_5556# a_n132_26472# vdd pfet_05v0 ad=0.3782p pd=1.84u as=0.3782p ps=1.84u w=1.22u l=0.5u
X177 vss a_33552_472# a_n132_9672# vss nfet_05v0 ad=0.2132p pd=1.34u as=0.2132p ps=1.34u w=0.82u l=0.6u
X178 vss a_33552_3608# a_n132_19272# vss nfet_05v0 ad=0.2132p pd=1.34u as=0.2132p ps=1.34u w=0.82u l=0.6u
X179 vdd dac_code[4] a_33552_3608# vdd pfet_05v0 ad=0.3782p pd=1.84u as=0.3782p ps=1.84u w=1.22u l=0.5u
X180 a_n132_9672# a_33552_472# vss vss nfet_05v0 ad=0.2132p pd=1.34u as=0.2132p ps=1.34u w=0.82u l=0.6u
X181 vdd a_33552_5176# a_n132_24072# vdd pfet_05v0 ad=0.3782p pd=1.84u as=0.3782p ps=1.84u w=1.22u l=0.5u
X182 vdd a_33552_2040# a_n132_14472# vdd pfet_05v0 ad=0.3782p pd=1.84u as=0.3782p ps=1.84u w=1.22u l=0.5u
X183 a_n132_19272# a_33552_3608# vss vss nfet_05v0 ad=0.2132p pd=1.34u as=0.2132p ps=1.34u w=0.82u l=0.6u
X184 a_33552_2040# dac_code[2] vdd vdd pfet_05v0 ad=0.3782p pd=1.84u as=0.3782p ps=1.84u w=1.22u l=0.5u
X185 vdd dac_code[1] a_33552_852# vdd pfet_05v0 ad=0.3782p pd=1.84u as=0.3782p ps=1.84u w=1.22u l=0.5u
X186 a_n132_16872# a_33552_2420# vss vss nfet_05v0 ad=0.2132p pd=1.34u as=0.2132p ps=1.34u w=0.82u l=0.6u
X187 a_n132_26472# a_33552_5556# vss vss nfet_05v0 ad=0.2132p pd=1.34u as=0.2132p ps=1.34u w=0.82u l=0.6u
X188 a_n132_24072# a_33552_5176# vdd vdd pfet_05v0 ad=0.3782p pd=1.84u as=0.3782p ps=1.84u w=1.22u l=0.5u
X189 vdd dac_code[7] a_33552_5556# vdd pfet_05v0 ad=0.3782p pd=1.84u as=0.3782p ps=1.84u w=1.22u l=0.5u
X190 vss dac_code[4] a_33552_3608# vss nfet_05v0 ad=0.2132p pd=1.34u as=0.2132p ps=1.34u w=0.82u l=0.6u
X191 a_33552_3608# dac_code[4] vdd vdd pfet_05v0 ad=0.3782p pd=1.84u as=0.3782p ps=1.84u w=1.22u l=0.5u
X192 vss dac_code[0] a_33552_472# vss nfet_05v0 ad=0.2132p pd=1.34u as=0.2132p ps=1.34u w=0.82u l=0.6u
X193 vss dac_code[3] a_33552_2420# vss nfet_05v0 ad=0.2132p pd=1.34u as=0.2132p ps=1.34u w=0.82u l=0.6u
X194 vdd dac_code[2] a_33552_2040# vdd pfet_05v0 ad=0.3782p pd=1.84u as=0.3782p ps=1.84u w=1.22u l=0.5u
X195 vss a_33552_5556# a_n132_26472# vss nfet_05v0 ad=0.2132p pd=1.34u as=0.2132p ps=1.34u w=0.82u l=0.6u
X196 a_n132_19272# a_33552_3608# vdd vdd pfet_05v0 ad=0.3782p pd=1.84u as=0.3782p ps=1.84u w=1.22u l=0.5u
X197 a_n132_21672# a_33552_3988# vdd vdd pfet_05v0 ad=0.3782p pd=1.84u as=0.3782p ps=1.84u w=1.22u l=0.5u
X198 a_33552_5556# dac_code[7] vdd vdd pfet_05v0 ad=0.3782p pd=1.84u as=0.3782p ps=1.84u w=1.22u l=0.5u
X199 a_33552_3608# dac_code[4] vss vss nfet_05v0 ad=0.2132p pd=1.34u as=0.2132p ps=1.34u w=0.82u l=0.6u
X200 vss a_33552_2420# a_n132_16872# vss nfet_05v0 ad=0.2132p pd=1.34u as=0.2132p ps=1.34u w=0.82u l=0.6u
X201 a_33552_2040# dac_code[2] vdd vdd pfet_05v0 ad=0.3782p pd=1.84u as=0.5368p ps=3.32u w=1.22u l=0.5u
X202 vdd a_33552_2040# a_n132_14472# vdd pfet_05v0 ad=0.5368p pd=3.32u as=0.3782p ps=1.84u w=1.22u l=0.5u
X203 a_n132_16872# a_33552_2420# vss vss nfet_05v0 ad=0.2132p pd=1.34u as=0.2132p ps=1.34u w=0.82u l=0.6u
X204 vdd a_33552_852# a_n132_12072# vdd pfet_05v0 ad=0.3782p pd=1.84u as=0.3782p ps=1.84u w=1.22u l=0.5u
X205 vdd a_33552_3608# a_n132_19272# vdd pfet_05v0 ad=0.3782p pd=1.84u as=0.3782p ps=1.84u w=1.22u l=0.5u
X206 vdd a_33552_3988# a_n132_21672# vdd pfet_05v0 ad=0.3782p pd=1.84u as=0.3782p ps=1.84u w=1.22u l=0.5u
X207 a_n132_26472# a_33552_5556# vss vss nfet_05v0 ad=0.2132p pd=1.34u as=0.2132p ps=1.34u w=0.82u l=0.6u
X208 a_33552_472# dac_code[0] vdd vdd pfet_05v0 ad=0.3782p pd=1.84u as=0.3782p ps=1.84u w=1.22u l=0.5u
X209 a_n132_26472# a_33552_5556# vdd vdd pfet_05v0 ad=0.3782p pd=1.84u as=0.3782p ps=1.84u w=1.22u l=0.5u
X210 a_n132_19272# a_33552_3608# vss vss nfet_05v0 ad=0.2132p pd=1.34u as=0.2132p ps=1.34u w=0.82u l=0.6u
X211 a_33552_3608# dac_code[4] vdd vdd pfet_05v0 ad=0.3782p pd=1.84u as=0.3782p ps=1.84u w=1.22u l=0.5u
X212 a_33552_472# dac_code[0] vss vss nfet_05v0 ad=0.2132p pd=1.34u as=0.3608p ps=2.52u w=0.82u l=0.6u
X213 a_n132_24072# a_33552_5176# vdd vdd pfet_05v0 ad=0.3782p pd=1.84u as=0.3782p ps=1.84u w=1.22u l=0.5u
X214 a_n132_14472# a_33552_2040# vdd vdd pfet_05v0 ad=0.3782p pd=1.84u as=0.3782p ps=1.84u w=1.22u l=0.5u
X215 vdd dac_code[2] a_33552_2040# vdd pfet_05v0 ad=0.3782p pd=1.84u as=0.3782p ps=1.84u w=1.22u l=0.5u
X216 vss dac_code[7] a_33552_5556# vss nfet_05v0 ad=0.2132p pd=1.34u as=0.2132p ps=1.34u w=0.82u l=0.6u
X217 vdd a_33552_5556# a_n132_26472# vdd pfet_05v0 ad=0.3782p pd=1.84u as=0.3782p ps=1.84u w=1.22u l=0.5u
X218 vss a_33552_2420# a_n132_16872# vss nfet_05v0 ad=0.2132p pd=1.34u as=0.2132p ps=1.34u w=0.82u l=0.6u
X219 vdd a_33552_5176# a_n132_24072# vdd pfet_05v0 ad=0.3782p pd=1.84u as=0.3782p ps=1.84u w=1.22u l=0.5u
X220 a_n132_24072# a_29672_23272# vss ppolyf_u r_width=2u r_length=0.15m
X221 a_33552_5556# dac_code[7] vdd vdd pfet_05v0 ad=0.3782p pd=1.84u as=0.3782p ps=1.84u w=1.22u l=0.5u
X222 a_n132_19272# a_33552_3608# vss vss nfet_05v0 ad=0.2132p pd=1.34u as=0.2132p ps=1.34u w=0.82u l=0.6u
X223 vdd dac_code[4] a_33552_3608# vdd pfet_05v0 ad=0.3782p pd=1.84u as=0.3782p ps=1.84u w=1.22u l=0.5u
X224 a_n132_12872# a_29672_13672# vss ppolyf_u r_width=2u r_length=0.14836m
X225 vdd a_33552_2040# a_n132_14472# vdd pfet_05v0 ad=0.3782p pd=1.84u as=0.3782p ps=1.84u w=1.22u l=0.5u
X226 vss a_33552_472# a_n132_9672# vss nfet_05v0 ad=0.2132p pd=1.34u as=0.2132p ps=1.34u w=0.82u l=0.6u
X227 a_n132_16872# a_33552_2420# vss vss nfet_05v0 ad=0.2132p pd=1.34u as=0.2132p ps=1.34u w=0.82u l=0.6u
X228 vss a_33552_5556# a_n132_26472# vss nfet_05v0 ad=0.2132p pd=1.34u as=0.2132p ps=1.34u w=0.82u l=0.6u
X229 a_n132_14472# a_33552_2040# vdd vdd pfet_05v0 ad=0.3782p pd=1.84u as=0.3782p ps=1.84u w=1.22u l=0.5u
X230 a_n132_26472# a_33552_5556# vss vss nfet_05v0 ad=0.2132p pd=1.34u as=0.2132p ps=1.34u w=0.82u l=0.6u
X231 a_33552_3608# dac_code[4] vdd vdd pfet_05v0 ad=0.3782p pd=1.84u as=0.5368p ps=3.32u w=1.22u l=0.5u
X232 vdd a_33552_3608# a_n132_19272# vdd pfet_05v0 ad=0.5368p pd=3.32u as=0.3782p ps=1.84u w=1.22u l=0.5u
X233 a_n132_19272# a_29672_18472# vss ppolyf_u r_width=2u r_length=0.15m
X234 vdd dac_code[7] a_33552_5556# vdd pfet_05v0 ad=0.3782p pd=1.84u as=0.3782p ps=1.84u w=1.22u l=0.5u
X235 vss a_33552_3608# a_n132_19272# vss nfet_05v0 ad=0.2132p pd=1.34u as=0.2132p ps=1.34u w=0.82u l=0.6u
X236 vdd dac_code[0] a_33552_472# vdd pfet_05v0 ad=0.3782p pd=1.84u as=0.3782p ps=1.84u w=1.22u l=0.5u
X237 vdd dac_code[2] a_33552_2040# vdd pfet_05v0 ad=0.3782p pd=1.84u as=0.3782p ps=1.84u w=1.22u l=0.5u
X238 a_n132_19272# a_33552_3608# vdd vdd pfet_05v0 ad=0.3782p pd=1.84u as=0.3782p ps=1.84u w=1.22u l=0.5u
X239 a_n132_21672# a_33552_3988# vdd vdd pfet_05v0 ad=0.3782p pd=1.84u as=0.3782p ps=1.84u w=1.22u l=0.5u
X240 vss a_33552_5556# a_n132_26472# vss nfet_05v0 ad=0.2132p pd=1.34u as=0.2132p ps=1.34u w=0.82u l=0.6u
X241 a_33552_5556# dac_code[7] vdd vdd pfet_05v0 ad=0.3782p pd=1.84u as=0.5368p ps=3.32u w=1.22u l=0.5u
X242 a_n132_9672# a_33552_472# vdd vdd pfet_05v0 ad=0.3782p pd=1.84u as=0.3782p ps=1.84u w=1.22u l=0.5u
X243 vdd dac_code[4] a_33552_3608# vdd pfet_05v0 ad=0.3782p pd=1.84u as=0.3782p ps=1.84u w=1.22u l=0.5u
X244 vdd a_33552_5556# a_n132_26472# vdd pfet_05v0 ad=0.5368p pd=3.32u as=0.3782p ps=1.84u w=1.22u l=0.5u
X245 a_n132_19272# a_33552_3608# vss vss nfet_05v0 ad=0.2132p pd=1.34u as=0.2132p ps=1.34u w=0.82u l=0.6u
X246 a_33552_2040# dac_code[2] vdd vdd pfet_05v0 ad=0.3782p pd=1.84u as=0.3782p ps=1.84u w=1.22u l=0.5u
X247 a_n132_26472# a_33552_5556# vss vss nfet_05v0 ad=0.2132p pd=1.34u as=0.2132p ps=1.34u w=0.82u l=0.6u
X248 a_n132_16872# a_33552_2420# vss vss nfet_05v0 ad=0.2132p pd=1.34u as=0.2132p ps=1.34u w=0.82u l=0.6u
X249 a_n132_26472# a_33552_5556# vdd vdd pfet_05v0 ad=0.3782p pd=1.84u as=0.3782p ps=1.84u w=1.22u l=0.5u
X250 vdd a_33552_3608# a_n132_19272# vdd pfet_05v0 ad=0.3782p pd=1.84u as=0.3782p ps=1.84u w=1.22u l=0.5u
X251 vdd a_33552_3988# a_n132_21672# vdd pfet_05v0 ad=0.3782p pd=1.84u as=0.3782p ps=1.84u w=1.22u l=0.5u
X252 vdd dac_code[7] a_33552_5556# vdd pfet_05v0 ad=0.3782p pd=1.84u as=0.3782p ps=1.84u w=1.22u l=0.5u
X253 a_n132_24072# a_33552_5176# vdd vdd pfet_05v0 ad=0.3782p pd=1.84u as=0.3782p ps=1.84u w=1.22u l=0.5u
X254 vss dac_code[4] a_33552_3608# vss nfet_05v0 ad=0.2132p pd=1.34u as=0.2132p ps=1.34u w=0.82u l=0.6u
X255 a_n132_19272# a_33552_3608# vdd vdd pfet_05v0 ad=0.3782p pd=1.84u as=0.3782p ps=1.84u w=1.22u l=0.5u
X256 a_n132_14472# a_33552_2040# vdd vdd pfet_05v0 ad=0.3782p pd=1.84u as=0.3782p ps=1.84u w=1.22u l=0.5u
X257 vss a_33552_2420# a_n132_16872# vss nfet_05v0 ad=0.2132p pd=1.34u as=0.2132p ps=1.34u w=0.82u l=0.6u
X258 a_n132_12072# a_33552_852# vdd vdd pfet_05v0 ad=0.3782p pd=1.84u as=0.3782p ps=1.84u w=1.22u l=0.5u
X259 vdd a_33552_5556# a_n132_26472# vdd pfet_05v0 ad=0.3782p pd=1.84u as=0.3782p ps=1.84u w=1.22u l=0.5u
X260 vss a_33552_3608# a_n132_19272# vss nfet_05v0 ad=0.2132p pd=1.34u as=0.2132p ps=1.34u w=0.82u l=0.6u
X261 vdd dac_code[4] a_33552_3608# vdd pfet_05v0 ad=0.3782p pd=1.84u as=0.3782p ps=1.84u w=1.22u l=0.5u
X262 vdd a_33552_5176# a_n132_24072# vdd pfet_05v0 ad=0.3782p pd=1.84u as=0.3782p ps=1.84u w=1.22u l=0.5u
X263 a_n132_26472# a_33552_5556# vdd vdd pfet_05v0 ad=0.3782p pd=1.84u as=0.3782p ps=1.84u w=1.22u l=0.5u
X264 a_n132_19272# a_33552_3608# vss vss nfet_05v0 ad=0.2132p pd=1.34u as=0.2132p ps=1.34u w=0.82u l=0.6u
X265 vdd a_33552_472# a_n132_9672# vdd pfet_05v0 ad=0.3782p pd=1.84u as=0.3782p ps=1.84u w=1.22u l=0.5u
X266 a_n132_14472# a_33552_2040# vdd vdd pfet_05v0 ad=0.3782p pd=1.84u as=0.3782p ps=1.84u w=1.22u l=0.5u
X267 vss a_33552_472# a_n132_9672# vss nfet_05v0 ad=0.2132p pd=1.34u as=0.2132p ps=1.34u w=0.82u l=0.6u
X268 vss a_33552_472# a_n132_9672# vss nfet_05v0 ad=0.2132p pd=1.34u as=0.2132p ps=1.34u w=0.82u l=0.6u
X269 a_n132_26472# a_33552_5556# vss vss nfet_05v0 ad=0.2132p pd=1.34u as=0.2132p ps=1.34u w=0.82u l=0.6u
X270 vdd dac_code[7] a_33552_5556# vdd pfet_05v0 ad=0.3782p pd=1.84u as=0.3782p ps=1.84u w=1.22u l=0.5u
X271 a_33552_3608# dac_code[4] vdd vdd pfet_05v0 ad=0.3782p pd=1.84u as=0.3782p ps=1.84u w=1.22u l=0.5u
X272 vout a_29672_25672# vss ppolyf_u r_width=2u r_length=0.14836m
X273 vdd a_33552_2420# a_n132_16872# vdd pfet_05v0 ad=0.3782p pd=1.84u as=0.3782p ps=1.84u w=1.22u l=0.5u
X274 vss a_33552_3608# a_n132_19272# vss nfet_05v0 ad=0.2132p pd=1.34u as=0.2132p ps=1.34u w=0.82u l=0.6u
X275 vdd a_33552_2040# a_n132_14472# vdd pfet_05v0 ad=0.3782p pd=1.84u as=0.3782p ps=1.84u w=1.22u l=0.5u
X276 vss a_33552_5556# a_n132_26472# vss nfet_05v0 ad=0.2132p pd=1.34u as=0.2132p ps=1.34u w=0.82u l=0.6u
X277 a_n132_8072# a_n132_7272# vss ppolyf_u r_width=2u r_length=0.15m
X278 a_n132_19272# a_33552_3608# vdd vdd pfet_05v0 ad=0.3782p pd=1.84u as=0.3782p ps=1.84u w=1.22u l=0.5u
X279 vdd dac_code[1] a_33552_852# vdd pfet_05v0 ad=0.3782p pd=1.84u as=0.3782p ps=1.84u w=1.22u l=0.5u
X280 a_33552_5556# dac_code[7] vdd vdd pfet_05v0 ad=0.3782p pd=1.84u as=0.3782p ps=1.84u w=1.22u l=0.5u
X281 a_33552_2420# dac_code[3] vdd vdd pfet_05v0 ad=0.3782p pd=1.84u as=0.3782p ps=1.84u w=1.22u l=0.5u
X282 a_n132_19272# a_33552_3608# vss vss nfet_05v0 ad=0.2132p pd=1.34u as=0.2132p ps=1.34u w=0.82u l=0.6u
X283 a_n132_20072# a_n132_17672# vss ppolyf_u r_width=2u r_length=0.15m
X284 a_n132_14472# a_33552_2040# vdd vdd pfet_05v0 ad=0.3782p pd=1.84u as=0.3782p ps=1.84u w=1.22u l=0.5u
X285 a_n132_16872# a_33552_2420# vss vss nfet_05v0 ad=0.2132p pd=1.34u as=0.2132p ps=1.34u w=0.82u l=0.6u
X286 a_n132_12072# a_33552_852# vdd vdd pfet_05v0 ad=0.3782p pd=1.84u as=0.3782p ps=1.84u w=1.22u l=0.5u
X287 a_n132_9672# a_33552_472# vss vss nfet_05v0 ad=0.2132p pd=1.34u as=0.2132p ps=1.34u w=0.82u l=0.6u
X288 a_n132_9672# a_33552_472# vss vss nfet_05v0 ad=0.2132p pd=1.34u as=0.2132p ps=1.34u w=0.82u l=0.6u
X289 a_33552_472# dac_code[0] vdd vdd pfet_05v0 ad=0.3782p pd=1.84u as=0.3782p ps=1.84u w=1.22u l=0.5u
X290 a_n132_26472# a_33552_5556# vdd vdd pfet_05v0 ad=0.3782p pd=1.84u as=0.3782p ps=1.84u w=1.22u l=0.5u
X291 a_n132_19272# a_33552_3608# vdd vdd pfet_05v0 ad=0.3782p pd=1.84u as=0.3782p ps=1.84u w=1.22u l=0.5u
X292 vdd dac_code[2] a_33552_2040# vdd pfet_05v0 ad=0.3782p pd=1.84u as=0.3782p ps=1.84u w=1.22u l=0.5u
X293 vdd a_33552_472# a_n132_9672# vdd pfet_05v0 ad=0.3782p pd=1.84u as=0.3782p ps=1.84u w=1.22u l=0.5u
X294 vss a_33552_852# a_n132_12072# vss nfet_05v0 ad=0.2132p pd=1.34u as=0.2132p ps=1.34u w=0.82u l=0.6u
X295 vss a_33552_3988# a_n132_21672# vss nfet_05v0 ad=0.2132p pd=1.34u as=0.2132p ps=1.34u w=0.82u l=0.6u
X296 a_n132_15272# a_n132_12872# vss ppolyf_u r_width=2u r_length=0.15m
X297 vss a_33552_2420# a_n132_16872# vss nfet_05v0 ad=0.2132p pd=1.34u as=0.2132p ps=1.34u w=0.82u l=0.6u
X298 a_n132_26472# a_33552_5556# vdd vdd pfet_05v0 ad=0.3782p pd=1.84u as=0.3782p ps=1.84u w=1.22u l=0.5u
X299 vdd a_33552_852# a_n132_12072# vdd pfet_05v0 ad=0.5368p pd=3.32u as=0.3782p ps=1.84u w=1.22u l=0.5u
X300 vdd a_33552_3608# a_n132_19272# vdd pfet_05v0 ad=0.3782p pd=1.84u as=0.3782p ps=1.84u w=1.22u l=0.5u
X301 vdd a_33552_472# a_n132_9672# vdd pfet_05v0 ad=0.3782p pd=1.84u as=0.3782p ps=1.84u w=1.22u l=0.5u
X302 a_33552_3988# dac_code[5] vss vss nfet_05v0 ad=0.2132p pd=1.34u as=0.2132p ps=1.34u w=0.82u l=0.6u
X303 a_33552_852# dac_code[1] vss vss nfet_05v0 ad=0.2132p pd=1.34u as=0.2132p ps=1.34u w=0.82u l=0.6u
X304 vdd a_33552_2040# a_n132_14472# vdd pfet_05v0 ad=0.3782p pd=1.84u as=0.3782p ps=1.84u w=1.22u l=0.5u
X305 a_n132_19272# a_33552_3608# vss vss nfet_05v0 ad=0.2132p pd=1.34u as=0.2132p ps=1.34u w=0.82u l=0.6u
X306 a_33552_852# dac_code[1] vdd vdd pfet_05v0 ad=0.3782p pd=1.84u as=0.3782p ps=1.84u w=1.22u l=0.5u
X307 a_n132_14472# a_33552_2040# vdd vdd pfet_05v0 ad=0.3782p pd=1.84u as=0.3782p ps=1.84u w=1.22u l=0.5u
X308 a_n132_26472# a_33552_5556# vss vss nfet_05v0 ad=0.2132p pd=1.34u as=0.2132p ps=1.34u w=0.82u l=0.6u
X309 a_n132_9672# a_33552_472# vdd vdd pfet_05v0 ad=0.3782p pd=1.84u as=0.3782p ps=1.84u w=1.22u l=0.5u
X310 vdd a_33552_5556# a_n132_26472# vdd pfet_05v0 ad=0.3782p pd=1.84u as=0.3782p ps=1.84u w=1.22u l=0.5u
X311 vdd a_33552_852# a_n132_12072# vdd pfet_05v0 ad=0.3782p pd=1.84u as=0.3782p ps=1.84u w=1.22u l=0.5u
X312 vss a_33552_3608# a_n132_19272# vss nfet_05v0 ad=0.2132p pd=1.34u as=0.2132p ps=1.34u w=0.82u l=0.6u
X313 a_n132_19272# a_33552_3608# vdd vdd pfet_05v0 ad=0.3782p pd=1.84u as=0.3782p ps=1.84u w=1.22u l=0.5u
X314 vdd dac_code[0] a_33552_472# vdd pfet_05v0 ad=0.3782p pd=1.84u as=0.3782p ps=1.84u w=1.22u l=0.5u
X315 vss a_33552_472# a_n132_9672# vss nfet_05v0 ad=0.2132p pd=1.34u as=0.2132p ps=1.34u w=0.82u l=0.6u
X316 vdd a_33552_2420# a_n132_16872# vdd pfet_05v0 ad=0.3782p pd=1.84u as=0.3782p ps=1.84u w=1.22u l=0.5u
X317 vdd a_33552_2040# a_n132_14472# vdd pfet_05v0 ad=0.3782p pd=1.84u as=0.3782p ps=1.84u w=1.22u l=0.5u
X318 vss a_33552_5556# a_n132_26472# vss nfet_05v0 ad=0.2132p pd=1.34u as=0.2132p ps=1.34u w=0.82u l=0.6u
X319 vdd dac_code[4] a_33552_3608# vdd pfet_05v0 ad=0.3782p pd=1.84u as=0.3782p ps=1.84u w=1.22u l=0.5u
X320 a_n132_26472# a_33552_5556# vdd vdd pfet_05v0 ad=0.3782p pd=1.84u as=0.3782p ps=1.84u w=1.22u l=0.5u
X321 a_n132_14472# a_33552_2040# vdd vdd pfet_05v0 ad=0.3782p pd=1.84u as=0.3782p ps=1.84u w=1.22u l=0.5u
X322 a_33552_852# dac_code[1] vdd vdd pfet_05v0 ad=0.3782p pd=1.84u as=0.3782p ps=1.84u w=1.22u l=0.5u
X323 a_n132_12072# a_33552_852# vdd vdd pfet_05v0 ad=0.3782p pd=1.84u as=0.3782p ps=1.84u w=1.22u l=0.5u
X324 vdd dac_code[3] a_33552_2420# vdd pfet_05v0 ad=0.3782p pd=1.84u as=0.3782p ps=1.84u w=1.22u l=0.5u
X325 vss a_33552_2040# a_n132_14472# vss nfet_05v0 ad=0.2132p pd=1.34u as=0.2132p ps=1.34u w=0.82u l=0.6u
X326 vdd a_33552_3608# a_n132_19272# vdd pfet_05v0 ad=0.3782p pd=1.84u as=0.3782p ps=1.84u w=1.22u l=0.5u
X327 vss a_33552_5176# a_n132_24072# vss nfet_05v0 ad=0.2132p pd=1.34u as=0.2132p ps=1.34u w=0.82u l=0.6u
X328 a_n132_9672# a_29672_8872# vss ppolyf_u r_width=2u r_length=0.15m
X329 vdd dac_code[7] a_33552_5556# vdd pfet_05v0 ad=0.3782p pd=1.84u as=0.3782p ps=1.84u w=1.22u l=0.5u
X330 vss a_33552_472# a_n132_9672# vss nfet_05v0 ad=0.2132p pd=1.34u as=0.2132p ps=1.34u w=0.82u l=0.6u
X331 a_n132_19272# a_33552_3608# vdd vdd pfet_05v0 ad=0.3782p pd=1.84u as=0.3782p ps=1.84u w=1.22u l=0.5u
X332 vdd a_33552_472# a_n132_9672# vdd pfet_05v0 ad=0.3782p pd=1.84u as=0.3782p ps=1.84u w=1.22u l=0.5u
X333 a_n132_9672# a_33552_472# vss vss nfet_05v0 ad=0.2132p pd=1.34u as=0.2132p ps=1.34u w=0.82u l=0.6u
X334 a_33552_5176# dac_code[6] vss vss nfet_05v0 ad=0.2132p pd=1.34u as=0.2132p ps=1.34u w=0.82u l=0.6u
X335 a_n132_12072# a_33552_852# vdd vdd pfet_05v0 ad=0.3782p pd=1.84u as=0.3782p ps=1.84u w=1.22u l=0.5u
X336 a_n132_21672# a_29672_20872# vss ppolyf_u r_width=2u r_length=0.15m
X337 vss a_33552_852# a_n132_12072# vss nfet_05v0 ad=0.2132p pd=1.34u as=0.2132p ps=1.34u w=0.82u l=0.6u
X338 a_33552_2040# dac_code[2] vss vss nfet_05v0 ad=0.2132p pd=1.34u as=0.2132p ps=1.34u w=0.82u l=0.6u
X339 vss a_33552_3988# a_n132_21672# vss nfet_05v0 ad=0.2132p pd=1.34u as=0.2132p ps=1.34u w=0.82u l=0.6u
X340 a_33552_2420# dac_code[3] vdd vdd pfet_05v0 ad=0.3782p pd=1.84u as=0.3782p ps=1.84u w=1.22u l=0.5u
X341 vdd a_33552_5556# a_n132_26472# vdd pfet_05v0 ad=0.3782p pd=1.84u as=0.3782p ps=1.84u w=1.22u l=0.5u
X342 a_n132_26472# a_33552_5556# vdd vdd pfet_05v0 ad=0.3782p pd=1.84u as=0.3782p ps=1.84u w=1.22u l=0.5u
X343 a_n132_19272# a_33552_3608# vss vss nfet_05v0 ad=0.2132p pd=1.34u as=0.2132p ps=1.34u w=0.82u l=0.6u
X344 vdd a_33552_3608# a_n132_19272# vdd pfet_05v0 ad=0.3782p pd=1.84u as=0.3782p ps=1.84u w=1.22u l=0.5u
X345 a_n132_16872# a_33552_2420# vdd vdd pfet_05v0 ad=0.3782p pd=1.84u as=0.3782p ps=1.84u w=1.22u l=0.5u
X346 vss dac_code[5] a_33552_3988# vss nfet_05v0 ad=0.2132p pd=1.34u as=0.2132p ps=1.34u w=0.82u l=0.6u
X347 vss dac_code[1] a_33552_852# vss nfet_05v0 ad=0.2132p pd=1.34u as=0.2132p ps=1.34u w=0.82u l=0.6u
X348 a_n132_14472# a_33552_2040# vdd vdd pfet_05v0 ad=0.3782p pd=1.84u as=0.3782p ps=1.84u w=1.22u l=0.5u
X349 a_n132_16872# a_29672_16072# vss ppolyf_u r_width=2u r_length=0.15m
X350 vdd a_33552_852# a_n132_12072# vdd pfet_05v0 ad=0.3782p pd=1.84u as=0.3782p ps=1.84u w=1.22u l=0.5u
X351 a_n132_19272# a_33552_3608# vdd vdd pfet_05v0 ad=0.3782p pd=1.84u as=0.3782p ps=1.84u w=1.22u l=0.5u
X352 vdd a_33552_5556# a_n132_26472# vdd pfet_05v0 ad=0.3782p pd=1.84u as=0.3782p ps=1.84u w=1.22u l=0.5u
X353 vdd a_33552_2420# a_n132_16872# vdd pfet_05v0 ad=0.3782p pd=1.84u as=0.3782p ps=1.84u w=1.22u l=0.5u
X354 vss a_33552_3608# a_n132_19272# vss nfet_05v0 ad=0.2132p pd=1.34u as=0.2132p ps=1.34u w=0.82u l=0.6u
X355 vdd a_33552_2040# a_n132_14472# vdd pfet_05v0 ad=0.3782p pd=1.84u as=0.3782p ps=1.84u w=1.22u l=0.5u
X356 a_33552_2420# dac_code[3] vdd vdd pfet_05v0 ad=0.3782p pd=1.84u as=0.3782p ps=1.84u w=1.22u l=0.5u
X357 a_33552_3988# dac_code[5] vss vss nfet_05v0 ad=0.2132p pd=1.34u as=0.2132p ps=1.34u w=0.82u l=0.6u
X358 a_33552_852# dac_code[1] vss vss nfet_05v0 ad=0.2132p pd=1.34u as=0.2132p ps=1.34u w=0.82u l=0.6u
X359 a_n132_9672# a_33552_472# vss vss nfet_05v0 ad=0.2132p pd=1.34u as=0.2132p ps=1.34u w=0.82u l=0.6u
X360 a_n132_26472# a_33552_5556# vdd vdd pfet_05v0 ad=0.3782p pd=1.84u as=0.3782p ps=1.84u w=1.22u l=0.5u
X361 a_n132_10472# a_29672_11272# vss ppolyf_u r_width=2u r_length=0.14836m
X362 a_n132_9672# a_33552_472# vdd vdd pfet_05v0 ad=0.3782p pd=1.84u as=0.3782p ps=1.84u w=1.22u l=0.5u
X363 a_n132_12072# a_33552_852# vss vss nfet_05v0 ad=0.2132p pd=1.34u as=0.2132p ps=1.34u w=0.82u l=0.6u
X364 a_n132_21672# a_33552_3988# vss vss nfet_05v0 ad=0.2132p pd=1.34u as=0.2132p ps=1.34u w=0.82u l=0.6u
X365 vdd dac_code[3] a_33552_2420# vdd pfet_05v0 ad=0.3782p pd=1.84u as=0.3782p ps=1.84u w=1.22u l=0.5u
X366 vss a_33552_2040# a_n132_14472# vss nfet_05v0 ad=0.2132p pd=1.34u as=0.2132p ps=1.34u w=0.82u l=0.6u
X367 vss a_33552_5176# a_n132_24072# vss nfet_05v0 ad=0.2132p pd=1.34u as=0.2132p ps=1.34u w=0.82u l=0.6u
X368 a_n132_19272# a_33552_3608# vdd vdd pfet_05v0 ad=0.3782p pd=1.84u as=0.3782p ps=1.84u w=1.22u l=0.5u
X369 vss a_33552_852# a_n132_12072# vss nfet_05v0 ad=0.2132p pd=1.34u as=0.2132p ps=1.34u w=0.82u l=0.6u
X370 vss a_33552_3988# a_n132_21672# vss nfet_05v0 ad=0.2132p pd=1.34u as=0.2132p ps=1.34u w=0.82u l=0.6u
X371 a_33552_2420# dac_code[3] vdd vdd pfet_05v0 ad=0.3782p pd=1.84u as=0.5368p ps=3.32u w=1.22u l=0.5u
X372 vss a_33552_472# a_n132_9672# vss nfet_05v0 ad=0.2132p pd=1.34u as=0.2132p ps=1.34u w=0.82u l=0.6u
X373 vdd a_33552_2420# a_n132_16872# vdd pfet_05v0 ad=0.5368p pd=3.32u as=0.3782p ps=1.84u w=1.22u l=0.5u
X374 vss dac_code[0] a_33552_472# vss nfet_05v0 ad=0.2132p pd=1.34u as=0.2132p ps=1.34u w=0.82u l=0.6u
X375 a_n132_9672# a_33552_472# vss vss nfet_05v0 ad=0.2132p pd=1.34u as=0.2132p ps=1.34u w=0.82u l=0.6u
X376 a_33552_852# dac_code[1] vss vss nfet_05v0 ad=0.2132p pd=1.34u as=0.2132p ps=1.34u w=0.82u l=0.6u
X377 a_33552_3988# dac_code[5] vss vss nfet_05v0 ad=0.2132p pd=1.34u as=0.2132p ps=1.34u w=0.82u l=0.6u
X378 vss dac_code[6] a_33552_5176# vss nfet_05v0 ad=0.2132p pd=1.34u as=0.2132p ps=1.34u w=0.82u l=0.6u
X379 a_33552_852# dac_code[1] vdd vdd pfet_05v0 ad=0.3782p pd=1.84u as=0.3782p ps=1.84u w=1.22u l=0.5u
X380 vdd a_33552_3608# a_n132_19272# vdd pfet_05v0 ad=0.3782p pd=1.84u as=0.3782p ps=1.84u w=1.22u l=0.5u
X381 vss dac_code[2] a_33552_2040# vss nfet_05v0 ad=0.2132p pd=1.34u as=0.2132p ps=1.34u w=0.82u l=0.6u
X382 a_n132_26472# a_33552_5556# vdd vdd pfet_05v0 ad=0.3782p pd=1.84u as=0.3782p ps=1.84u w=1.22u l=0.5u
X383 a_n132_16872# a_33552_2420# vdd vdd pfet_05v0 ad=0.3782p pd=1.84u as=0.3782p ps=1.84u w=1.22u l=0.5u
X384 a_n132_14472# a_33552_2040# vdd vdd pfet_05v0 ad=0.3782p pd=1.84u as=0.3782p ps=1.84u w=1.22u l=0.5u
X385 vdd dac_code[3] a_33552_2420# vdd pfet_05v0 ad=0.3782p pd=1.84u as=0.3782p ps=1.84u w=1.22u l=0.5u
X386 vdd dac_code[0] a_33552_472# vdd pfet_05v0 ad=0.3782p pd=1.84u as=0.3782p ps=1.84u w=1.22u l=0.5u
X387 vss dac_code[5] a_33552_3988# vss nfet_05v0 ad=0.2132p pd=1.34u as=0.2132p ps=1.34u w=0.82u l=0.6u
X388 vss dac_code[1] a_33552_852# vss nfet_05v0 ad=0.2132p pd=1.34u as=0.2132p ps=1.34u w=0.82u l=0.6u
X389 vdd a_33552_5556# a_n132_26472# vdd pfet_05v0 ad=0.3782p pd=1.84u as=0.3782p ps=1.84u w=1.22u l=0.5u
X390 a_33552_5176# dac_code[6] vss vss nfet_05v0 ad=0.2132p pd=1.34u as=0.2132p ps=1.34u w=0.82u l=0.6u
X391 a_33552_2040# dac_code[2] vss vss nfet_05v0 ad=0.2132p pd=1.34u as=0.2132p ps=1.34u w=0.82u l=0.6u
X392 a_n132_9672# a_33552_472# vdd vdd pfet_05v0 ad=0.3782p pd=1.84u as=0.3782p ps=1.84u w=1.22u l=0.5u
X393 vdd a_33552_2420# a_n132_16872# vdd pfet_05v0 ad=0.3782p pd=1.84u as=0.3782p ps=1.84u w=1.22u l=0.5u
X394 a_33552_3988# dac_code[5] vss vss nfet_05v0 ad=0.2132p pd=1.34u as=0.3608p ps=2.52u w=0.82u l=0.6u
X395 a_33552_852# dac_code[1] vss vss nfet_05v0 ad=0.2132p pd=1.34u as=0.3608p ps=2.52u w=0.82u l=0.6u
X396 vdd a_33552_2040# a_n132_14472# vdd pfet_05v0 ad=0.3782p pd=1.84u as=0.3782p ps=1.84u w=1.22u l=0.5u
X397 vss a_33552_3988# a_n132_21672# vss nfet_05v0 ad=0.3608p pd=2.52u as=0.2132p ps=1.34u w=0.82u l=0.6u
X398 vss a_33552_852# a_n132_12072# vss nfet_05v0 ad=0.3608p pd=2.52u as=0.2132p ps=1.34u w=0.82u l=0.6u
X399 a_n132_16872# a_33552_2420# vdd vdd pfet_05v0 ad=0.3782p pd=1.84u as=0.3782p ps=1.84u w=1.22u l=0.5u
X400 a_n132_14472# a_33552_2040# vss vss nfet_05v0 ad=0.2132p pd=1.34u as=0.2132p ps=1.34u w=0.82u l=0.6u
X401 a_n132_24072# a_33552_5176# vss vss nfet_05v0 ad=0.2132p pd=1.34u as=0.2132p ps=1.34u w=0.82u l=0.6u
X402 a_n132_21672# a_33552_3988# vss vss nfet_05v0 ad=0.2132p pd=1.34u as=0.2132p ps=1.34u w=0.82u l=0.6u
X403 vdd dac_code[1] a_33552_852# vdd pfet_05v0 ad=0.3782p pd=1.84u as=0.3782p ps=1.84u w=1.22u l=0.5u
X404 a_n132_12072# a_33552_852# vss vss nfet_05v0 ad=0.2132p pd=1.34u as=0.2132p ps=1.34u w=0.82u l=0.6u
X405 vdd dac_code[3] a_33552_2420# vdd pfet_05v0 ad=0.3782p pd=1.84u as=0.3782p ps=1.84u w=1.22u l=0.5u
X406 vss dac_code[1] a_33552_852# vss nfet_05v0 ad=0.2132p pd=1.34u as=0.2132p ps=1.34u w=0.82u l=0.6u
X407 vss dac_code[5] a_33552_3988# vss nfet_05v0 ad=0.2132p pd=1.34u as=0.2132p ps=1.34u w=0.82u l=0.6u
X408 vss a_33552_2040# a_n132_14472# vss nfet_05v0 ad=0.2132p pd=1.34u as=0.2132p ps=1.34u w=0.82u l=0.6u
X409 vdd a_33552_3988# a_n132_21672# vdd pfet_05v0 ad=0.3782p pd=1.84u as=0.3782p ps=1.84u w=1.22u l=0.5u
X410 vss a_33552_5176# a_n132_24072# vss nfet_05v0 ad=0.2132p pd=1.34u as=0.2132p ps=1.34u w=0.82u l=0.6u
X411 a_n132_22472# a_29672_23272# vss ppolyf_u r_width=2u r_length=0.14836m
X412 a_n132_12072# a_33552_852# vdd vdd pfet_05v0 ad=0.3782p pd=1.84u as=0.3782p ps=1.84u w=1.22u l=0.5u
X413 a_33552_2040# dac_code[2] vss vss nfet_05v0 ad=0.2132p pd=1.34u as=0.2132p ps=1.34u w=0.82u l=0.6u
X414 a_n132_19272# a_33552_3608# vdd vdd pfet_05v0 ad=0.3782p pd=1.84u as=0.3782p ps=1.84u w=1.22u l=0.5u
X415 a_33552_5176# dac_code[6] vss vss nfet_05v0 ad=0.2132p pd=1.34u as=0.2132p ps=1.34u w=0.82u l=0.6u
X416 a_n132_12872# a_n132_10472# vss ppolyf_u r_width=2u r_length=0.15m
X417 a_33552_472# dac_code[0] vdd vdd pfet_05v0 ad=0.3782p pd=1.84u as=0.5368p ps=3.32u w=1.22u l=0.5u
X418 vss a_33552_852# a_n132_12072# vss nfet_05v0 ad=0.2132p pd=1.34u as=0.2132p ps=1.34u w=0.82u l=0.6u
X419 a_33552_3988# dac_code[5] vdd vdd pfet_05v0 ad=0.3782p pd=1.84u as=0.3782p ps=1.84u w=1.22u l=0.5u
X420 vss a_33552_3988# a_n132_21672# vss nfet_05v0 ad=0.2132p pd=1.34u as=0.2132p ps=1.34u w=0.82u l=0.6u
X421 a_33552_2420# dac_code[3] vdd vdd pfet_05v0 ad=0.3782p pd=1.84u as=0.3782p ps=1.84u w=1.22u l=0.5u
X422 vdd a_33552_5176# a_n132_24072# vdd pfet_05v0 ad=0.3782p pd=1.84u as=0.3782p ps=1.84u w=1.22u l=0.5u
X423 vdd a_33552_472# a_n132_9672# vdd pfet_05v0 ad=0.3782p pd=1.84u as=0.3782p ps=1.84u w=1.22u l=0.5u
X424 a_n132_12072# a_33552_852# vss vss nfet_05v0 ad=0.2132p pd=1.34u as=0.2132p ps=1.34u w=0.82u l=0.6u
X425 a_n132_21672# a_33552_3988# vss vss nfet_05v0 ad=0.2132p pd=1.34u as=0.2132p ps=1.34u w=0.82u l=0.6u
X426 a_n132_17672# a_29672_18472# vss ppolyf_u r_width=2u r_length=0.14836m
X427 a_n132_26472# a_33552_5556# vdd vdd pfet_05v0 ad=0.3782p pd=1.84u as=0.3782p ps=1.84u w=1.22u l=0.5u
X428 vss a_33552_472# a_n132_9672# vss nfet_05v0 ad=0.2132p pd=1.34u as=0.2132p ps=1.34u w=0.82u l=0.6u
X429 vdd a_33552_3608# a_n132_19272# vdd pfet_05v0 ad=0.3782p pd=1.84u as=0.3782p ps=1.84u w=1.22u l=0.5u
X430 vss dac_code[6] a_33552_5176# vss nfet_05v0 ad=0.2132p pd=1.34u as=0.2132p ps=1.34u w=0.82u l=0.6u
X431 vss dac_code[2] a_33552_2040# vss nfet_05v0 ad=0.2132p pd=1.34u as=0.2132p ps=1.34u w=0.82u l=0.6u
X432 a_n132_16872# a_33552_2420# vdd vdd pfet_05v0 ad=0.3782p pd=1.84u as=0.3782p ps=1.84u w=1.22u l=0.5u
X433 vss dac_code[1] a_33552_852# vss nfet_05v0 ad=0.2132p pd=1.34u as=0.2132p ps=1.34u w=0.82u l=0.6u
X434 vss dac_code[5] a_33552_3988# vss nfet_05v0 ad=0.2132p pd=1.34u as=0.2132p ps=1.34u w=0.82u l=0.6u
X435 a_33552_5176# dac_code[6] vdd vdd pfet_05v0 ad=0.3782p pd=1.84u as=0.3782p ps=1.84u w=1.22u l=0.5u
X436 a_33552_5176# dac_code[6] vss vss nfet_05v0 ad=0.2132p pd=1.34u as=0.3608p ps=2.52u w=0.82u l=0.6u
X437 a_33552_2040# dac_code[2] vss vss nfet_05v0 ad=0.2132p pd=1.34u as=0.3608p ps=2.52u w=0.82u l=0.6u
X438 vss a_33552_5176# a_n132_24072# vss nfet_05v0 ad=0.3608p pd=2.52u as=0.2132p ps=1.34u w=0.82u l=0.6u
X439 vss a_33552_2040# a_n132_14472# vss nfet_05v0 ad=0.3608p pd=2.52u as=0.2132p ps=1.34u w=0.82u l=0.6u
X440 vdd a_33552_5556# a_n132_26472# vdd pfet_05v0 ad=0.3782p pd=1.84u as=0.3782p ps=1.84u w=1.22u l=0.5u
X441 a_n132_9672# a_33552_472# vdd vdd pfet_05v0 ad=0.3782p pd=1.84u as=0.3782p ps=1.84u w=1.22u l=0.5u
X442 vdd a_33552_852# a_n132_12072# vdd pfet_05v0 ad=0.3782p pd=1.84u as=0.3782p ps=1.84u w=1.22u l=0.5u
X443 a_n132_16872# a_33552_2420# vdd vdd pfet_05v0 ad=0.3782p pd=1.84u as=0.3782p ps=1.84u w=1.22u l=0.5u
X444 a_33552_3988# dac_code[5] vss vss nfet_05v0 ad=0.2132p pd=1.34u as=0.2132p ps=1.34u w=0.82u l=0.6u
X445 a_33552_852# dac_code[1] vss vss nfet_05v0 ad=0.2132p pd=1.34u as=0.2132p ps=1.34u w=0.82u l=0.6u
X446 a_n132_24072# a_33552_5176# vss vss nfet_05v0 ad=0.2132p pd=1.34u as=0.2132p ps=1.34u w=0.82u l=0.6u
X447 a_n132_14472# a_33552_2040# vss vss nfet_05v0 ad=0.2132p pd=1.34u as=0.2132p ps=1.34u w=0.82u l=0.6u
X448 a_33552_472# dac_code[0] vss vss nfet_05v0 ad=0.2132p pd=1.34u as=0.2132p ps=1.34u w=0.82u l=0.6u
X449 vss dac_code[6] a_33552_5176# vss nfet_05v0 ad=0.2132p pd=1.34u as=0.2132p ps=1.34u w=0.82u l=0.6u
X450 vss dac_code[2] a_33552_2040# vss nfet_05v0 ad=0.2132p pd=1.34u as=0.2132p ps=1.34u w=0.82u l=0.6u
X451 a_n132_9672# a_33552_472# vdd vdd pfet_05v0 ad=0.3782p pd=1.84u as=0.3782p ps=1.84u w=1.22u l=0.5u
X452 a_n132_21672# a_33552_3988# vss vss nfet_05v0 ad=0.2132p pd=1.34u as=0.2132p ps=1.34u w=0.82u l=0.6u
X453 a_n132_12072# a_33552_852# vss vss nfet_05v0 ad=0.2132p pd=1.34u as=0.2132p ps=1.34u w=0.82u l=0.6u
X454 vdd a_33552_2420# a_n132_16872# vdd pfet_05v0 ad=0.3782p pd=1.84u as=0.3782p ps=1.84u w=1.22u l=0.5u
X455 vss a_33552_2040# a_n132_14472# vss nfet_05v0 ad=0.2132p pd=1.34u as=0.2132p ps=1.34u w=0.82u l=0.6u
X456 vdd a_33552_3988# a_n132_21672# vdd pfet_05v0 ad=0.3782p pd=1.84u as=0.3782p ps=1.84u w=1.22u l=0.5u
X457 vss a_33552_5176# a_n132_24072# vss nfet_05v0 ad=0.2132p pd=1.34u as=0.2132p ps=1.34u w=0.82u l=0.6u
X458 vss a_33552_472# a_n132_9672# vss nfet_05v0 ad=0.3608p pd=2.52u as=0.2132p ps=1.34u w=0.82u l=0.6u
X459 a_n132_14472# a_33552_2040# vss vss nfet_05v0 ad=0.2132p pd=1.34u as=0.2132p ps=1.34u w=0.82u l=0.6u
X460 a_n132_24072# a_33552_5176# vss vss nfet_05v0 ad=0.2132p pd=1.34u as=0.2132p ps=1.34u w=0.82u l=0.6u
X461 vss a_33552_2420# a_n132_16872# vss nfet_05v0 ad=0.2132p pd=1.34u as=0.2132p ps=1.34u w=0.82u l=0.6u
X462 vdd a_33552_472# a_n132_9672# vdd pfet_05v0 ad=0.3782p pd=1.84u as=0.3782p ps=1.84u w=1.22u l=0.5u
X463 a_n132_12072# a_33552_852# vss vss nfet_05v0 ad=0.2132p pd=1.34u as=0.2132p ps=1.34u w=0.82u l=0.6u
X464 a_n132_21672# a_33552_3988# vss vss nfet_05v0 ad=0.2132p pd=1.34u as=0.2132p ps=1.34u w=0.82u l=0.6u
X465 a_n132_16872# a_33552_2420# vdd vdd pfet_05v0 ad=0.3782p pd=1.84u as=0.3782p ps=1.84u w=1.22u l=0.5u
X466 vss dac_code[6] a_33552_5176# vss nfet_05v0 ad=0.2132p pd=1.34u as=0.2132p ps=1.34u w=0.82u l=0.6u
X467 a_33552_852# dac_code[1] vdd vdd pfet_05v0 ad=0.3782p pd=1.84u as=0.3782p ps=1.84u w=1.22u l=0.5u
X468 vout a_n132_22472# vss ppolyf_u r_width=2u r_length=0.15m
X469 vdd a_33552_5176# a_n132_24072# vdd pfet_05v0 ad=0.3782p pd=1.84u as=0.3782p ps=1.84u w=1.22u l=0.5u
X470 vss dac_code[2] a_33552_2040# vss nfet_05v0 ad=0.2132p pd=1.34u as=0.2132p ps=1.34u w=0.82u l=0.6u
X471 vdd dac_code[5] a_33552_3988# vdd pfet_05v0 ad=0.3782p pd=1.84u as=0.3782p ps=1.84u w=1.22u l=0.5u
X472 a_33552_2420# dac_code[3] vss vss nfet_05v0 ad=0.2132p pd=1.34u as=0.2132p ps=1.34u w=0.82u l=0.6u
X473 vdd dac_code[3] a_33552_2420# vdd pfet_05v0 ad=0.3782p pd=1.84u as=0.3782p ps=1.84u w=1.22u l=0.5u
X474 vdd a_33552_852# a_n132_12072# vdd pfet_05v0 ad=0.3782p pd=1.84u as=0.3782p ps=1.84u w=1.22u l=0.5u
X475 a_33552_472# dac_code[0] vss vss nfet_05v0 ad=0.2132p pd=1.34u as=0.2132p ps=1.34u w=0.82u l=0.6u
X476 vss a_33552_472# a_n132_9672# vss nfet_05v0 ad=0.2132p pd=1.34u as=0.2132p ps=1.34u w=0.82u l=0.6u
X477 a_n132_7272# vss vss ppolyf_u r_width=2u r_length=0.15m
X478 vdd dac_code[0] a_33552_472# vdd pfet_05v0 ad=0.3782p pd=1.84u as=0.3782p ps=1.84u w=1.22u l=0.5u
X479 vss a_33552_852# a_n132_12072# vss nfet_05v0 ad=0.2132p pd=1.34u as=0.2132p ps=1.34u w=0.82u l=0.6u
X480 vss a_33552_3988# a_n132_21672# vss nfet_05v0 ad=0.2132p pd=1.34u as=0.2132p ps=1.34u w=0.82u l=0.6u
X481 a_33552_5176# dac_code[6] vss vss nfet_05v0 ad=0.2132p pd=1.34u as=0.2132p ps=1.34u w=0.82u l=0.6u
X482 a_33552_2040# dac_code[2] vss vss nfet_05v0 ad=0.2132p pd=1.34u as=0.2132p ps=1.34u w=0.82u l=0.6u
X483 a_33552_3988# dac_code[5] vdd vdd pfet_05v0 ad=0.3782p pd=1.84u as=0.3782p ps=1.84u w=1.22u l=0.5u
X484 vdd dac_code[6] a_33552_5176# vdd pfet_05v0 ad=0.3782p pd=1.84u as=0.3782p ps=1.84u w=1.22u l=0.5u
X485 vdd a_33552_852# a_n132_12072# vdd pfet_05v0 ad=0.3782p pd=1.84u as=0.3782p ps=1.84u w=1.22u l=0.5u
X486 vdd a_33552_2420# a_n132_16872# vdd pfet_05v0 ad=0.3782p pd=1.84u as=0.3782p ps=1.84u w=1.22u l=0.5u
X487 vss a_33552_5556# a_n132_26472# vss nfet_05v0 ad=0.2132p pd=1.34u as=0.2132p ps=1.34u w=0.82u l=0.6u
X488 a_n132_16872# a_33552_2420# vdd vdd pfet_05v0 ad=0.3782p pd=1.84u as=0.3782p ps=1.84u w=1.22u l=0.5u
X489 a_n132_21672# a_33552_3988# vss vss nfet_05v0 ad=0.2132p pd=1.34u as=0.2132p ps=1.34u w=0.82u l=0.6u
X490 a_n132_12072# a_33552_852# vss vss nfet_05v0 ad=0.2132p pd=1.34u as=0.2132p ps=1.34u w=0.82u l=0.6u
X491 a_n132_24072# a_33552_5176# vss vss nfet_05v0 ad=0.2132p pd=1.34u as=0.2132p ps=1.34u w=0.82u l=0.6u
X492 a_n132_12072# a_33552_852# vdd vdd pfet_05v0 ad=0.3782p pd=1.84u as=0.3782p ps=1.84u w=1.22u l=0.5u
X493 a_n132_14472# a_33552_2040# vss vss nfet_05v0 ad=0.2132p pd=1.34u as=0.2132p ps=1.34u w=0.82u l=0.6u
X494 a_n132_21672# a_33552_3988# vdd vdd pfet_05v0 ad=0.3782p pd=1.84u as=0.3782p ps=1.84u w=1.22u l=0.5u
X495 a_33552_5176# dac_code[6] vdd vdd pfet_05v0 ad=0.3782p pd=1.84u as=0.3782p ps=1.84u w=1.22u l=0.5u
X496 a_33552_5556# dac_code[7] vss vss nfet_05v0 ad=0.2132p pd=1.34u as=0.2132p ps=1.34u w=0.82u l=0.6u
X497 vdd dac_code[1] a_33552_852# vdd pfet_05v0 ad=0.3782p pd=1.84u as=0.3782p ps=1.84u w=1.22u l=0.5u
X498 a_n132_9672# a_33552_472# vss vss nfet_05v0 ad=0.2132p pd=1.34u as=0.2132p ps=1.34u w=0.82u l=0.6u
X499 vss dac_code[5] a_33552_3988# vss nfet_05v0 ad=0.2132p pd=1.34u as=0.2132p ps=1.34u w=0.82u l=0.6u
X500 a_n132_14472# a_29672_13672# vss ppolyf_u r_width=2u r_length=0.15m
X501 vss dac_code[1] a_33552_852# vss nfet_05v0 ad=0.2132p pd=1.34u as=0.2132p ps=1.34u w=0.82u l=0.6u
X502 vdd a_33552_472# a_n132_9672# vdd pfet_05v0 ad=0.3782p pd=1.84u as=0.3782p ps=1.84u w=1.22u l=0.5u
X503 vdd a_33552_3988# a_n132_21672# vdd pfet_05v0 ad=0.3782p pd=1.84u as=0.3782p ps=1.84u w=1.22u l=0.5u
X504 vdd a_33552_2420# a_n132_16872# vdd pfet_05v0 ad=0.3782p pd=1.84u as=0.3782p ps=1.84u w=1.22u l=0.5u
.ends
