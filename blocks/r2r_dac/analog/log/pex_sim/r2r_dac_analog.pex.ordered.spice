* NGSPICE file created from r2r_dac_analog.ext - technology: gf180mcuD

.subckt r2r_dac_analog dac_code[7] dac_code[6] dac_code[5] dac_code[4] dac_code[3] dac_code[2] dac_code[1] dac_code[0] vout vdd vss
X0 a_n132_14472.t21 a_33552_2040.t39 vss.t32 vss.t22 nfet_05v0 ad=0.2132p pd=1.34u as=0.2132p ps=1.34u w=0.82u l=0.6u
X1 a_33552_3988.t6 dac_code[5].t3 vdd.t287 vdd.t286 pfet_05v0 ad=0.3782p pd=1.84u as=0.3782p ps=1.84u w=1.22u l=0.5u
X2 a_n132_24072.t20 a_33552_5176.t39 vss.t214 vss.t213 nfet_05v0 ad=0.2132p pd=1.34u as=0.2132p ps=1.34u w=0.82u l=0.6u
X3 a_n132_24072.t14 a_33552_5176.t45 vdd.t341 vdd.t240 pfet_05v0 ad=0.3782p pd=1.84u as=0.3782p ps=1.84u w=1.22u l=0.5u
X4 vss.t124 a_33552_3988.t42 a_n132_21672.t37 vss.t123 nfet_05v0 ad=0.2132p pd=1.34u as=0.2132p ps=1.34u w=0.82u l=0.6u
X5 vss.t266 a_33552_852.t42 a_n132_12072.t38 vss.t99 nfet_05v0 ad=0.2132p pd=1.34u as=0.2132p ps=1.34u w=0.82u l=0.6u
X6 a_n132_16872.t3 a_33552_2420.t37 vdd.t172 vdd.t142 pfet_05v0 ad=0.3782p pd=1.84u as=0.3782p ps=1.84u w=1.22u l=0.5u
X7 vss.t64 a_33552_2420.t50 a_n132_16872.t30 vss.t35 nfet_05v0 ad=0.2132p pd=1.34u as=0.2132p ps=1.34u w=0.82u l=0.6u
X8 vdd.t61 a_33552_5176.t54 a_n132_24072.t5 vdd.t60 pfet_05v0 ad=0.3782p pd=1.84u as=0.3782p ps=1.84u w=1.22u l=0.5u
X9 a_n132_12072.t29 a_33552_852.t51 vss.t219 vss.t81 nfet_05v0 ad=0.2132p pd=1.34u as=0.2132p ps=1.34u w=0.82u l=0.6u
X10 a_n132_21672.t28 a_33552_3988.t51 vss.t152 vss.t151 nfet_05v0 ad=0.2132p pd=1.34u as=0.2132p ps=1.34u w=0.82u l=0.6u
X11 vss.t56 a_33552_2040.t36 a_n132_14472.t24 vss.t55 nfet_05v0 ad=0.2132p pd=1.34u as=0.2132p ps=1.34u w=0.82u l=0.6u
X12 vss.t370 a_33552_5176.t36 a_n132_24072.t23 vss.t332 nfet_05v0 ad=0.2132p pd=1.34u as=0.2132p ps=1.34u w=0.82u l=0.6u
X13 a_33552_5176.t6 dac_code[6].t13 vdd.t206 vdd.t205 pfet_05v0 ad=0.3782p pd=1.84u as=0.3782p ps=1.84u w=1.22u l=0.5u
X14 vdd.t293 dac_code[5].t0 a_33552_3988.t9 vdd.t292 pfet_05v0 ad=0.3782p pd=1.84u as=0.3782p ps=1.84u w=1.22u l=0.5u
X15 vdd.t128 a_33552_852.t26 a_n132_12072.t14 vdd.t87 pfet_05v0 ad=0.3782p pd=1.84u as=0.3782p ps=1.84u w=1.22u l=0.5u
X16 vss.t206 dac_code[3].t18 a_33552_2420.t11 vss.t205 nfet_05v0 ad=0.2132p pd=1.34u as=0.2132p ps=1.34u w=0.82u l=0.6u
X17 vss.t222 a_33552_852.t48 a_n132_12072.t32 vss.t91 nfet_05v0 ad=0.2132p pd=1.34u as=0.2132p ps=1.34u w=0.82u l=0.6u
X18 a_33552_3988.t0 dac_code[5].t9 vdd.t275 vdd.t274 pfet_05v0 ad=0.3782p pd=1.84u as=0.5368p ps=3.32u w=1.22u l=0.5u
X19 vss.t68 a_33552_3988.t48 a_n132_21672.t31 vss.t67 nfet_05v0 ad=0.2132p pd=1.34u as=0.2132p ps=1.34u w=0.82u l=0.6u
X20 vdd.t184 a_33552_3988.t20 a_n132_21672.t19 vdd.t180 pfet_05v0 ad=0.5368p pd=3.32u as=0.3782p ps=1.84u w=1.22u l=0.5u
X21 a_33552_472.t18 dac_code[0].t1 vss.t355 vss.t354 nfet_05v0 ad=0.2132p pd=1.34u as=0.2132p ps=1.34u w=0.82u l=0.6u
X22 vss.t5 a_33552_3608.t38 a_n132_19272.t22 vss.t4 nfet_05v0 ad=0.2132p pd=1.34u as=0.2132p ps=1.34u w=0.82u l=0.6u
X23 a_n132_24072.t26 a_33552_5176.t33 vss.t275 vss.t138 nfet_05v0 ad=0.2132p pd=1.34u as=0.2132p ps=1.34u w=0.82u l=0.6u
X24 vdd.t212 dac_code[6].t10 a_33552_5176.t9 vdd.t211 pfet_05v0 ad=0.3782p pd=1.84u as=0.3782p ps=1.84u w=1.22u l=0.5u
X25 a_n132_14472.t27 a_33552_2040.t33 vss.t74 vss.t73 nfet_05v0 ad=0.2132p pd=1.34u as=0.2132p ps=1.34u w=0.82u l=0.6u
X26 a_n132_21672.t22 a_33552_3988.t57 vss.t310 vss.t125 nfet_05v0 ad=0.2132p pd=1.34u as=0.2132p ps=1.34u w=0.82u l=0.6u
X27 a_n132_12072.t23 a_33552_852.t57 vss.t42 vss.t41 nfet_05v0 ad=0.2132p pd=1.34u as=0.2132p ps=1.34u w=0.82u l=0.6u
X28 a_33552_2420.t14 dac_code[3].t15 vss.t208 vss.t207 nfet_05v0 ad=0.2132p pd=1.34u as=0.2132p ps=1.34u w=0.82u l=0.6u
X29 a_n132_21672.t10 a_33552_3988.t29 vdd.t339 vdd.t130 pfet_05v0 ad=0.3782p pd=1.84u as=0.3782p ps=1.84u w=1.22u l=0.5u
X30 a_n132_8072# a_29672_8872# vss.t1 ppolyf_u r_width=2u r_length=0.14836m
X31 vss.t230 a_33552_5556.t50 a_n132_26472.t29 vss.t229 nfet_05v0 ad=0.2132p pd=1.34u as=0.2132p ps=1.34u w=0.82u l=0.6u
X32 a_n132_16872.t17 a_33552_2420.t23 vdd.t191 vdd.t4 pfet_05v0 ad=0.3782p pd=1.84u as=0.3782p ps=1.84u w=1.22u l=0.5u
X33 a_33552_3608.t12 dac_code[4].t7 vss.t314 vss.t195 nfet_05v0 ad=0.2132p pd=1.34u as=0.2132p ps=1.34u w=0.82u l=0.6u
X34 vss.t258 dac_code[2].t2 a_33552_2040.t17 vss.t257 nfet_05v0 ad=0.2132p pd=1.34u as=0.2132p ps=1.34u w=0.82u l=0.6u
X35 vdd.t281 dac_code[5].t6 a_33552_3988.t3 vdd.t280 pfet_05v0 ad=0.3782p pd=1.84u as=0.3782p ps=1.84u w=1.22u l=0.5u
X36 vss.t168 dac_code[6].t2 a_33552_5176.t17 vss.t167 nfet_05v0 ad=0.2132p pd=1.34u as=0.2132p ps=1.34u w=0.82u l=0.6u
X37 a_33552_5176.t0 dac_code[6].t19 vdd.t194 vdd.t193 pfet_05v0 ad=0.3782p pd=1.84u as=0.5368p ps=3.32u w=1.22u l=0.5u
X38 vdd.t239 a_33552_5176.t40 a_n132_24072.t19 vdd.t108 pfet_05v0 ad=0.5368p pd=3.32u as=0.3782p ps=1.84u w=1.22u l=0.5u
X39 a_n132_20072# a_29672_20872# vss.t1 ppolyf_u r_width=2u r_length=0.14836m
X40 vdd.t23 a_33552_2420.t32 a_n132_16872.t8 vdd.t22 pfet_05v0 ad=0.3782p pd=1.84u as=0.3782p ps=1.84u w=1.22u l=0.5u
X41 a_n132_16872.t35 a_33552_2420.t45 vss.t46 vss.t45 nfet_05v0 ad=0.2132p pd=1.34u as=0.2132p ps=1.34u w=0.82u l=0.6u
X42 vss.t100 a_33552_2040.t22 a_n132_14472.t38 vss.t99 nfet_05v0 ad=0.2132p pd=1.34u as=0.2132p ps=1.34u w=0.82u l=0.6u
X43 vdd.t190 a_33552_3988.t26 a_n132_21672.t13 vdd.t140 pfet_05v0 ad=0.3782p pd=1.84u as=0.3782p ps=1.84u w=1.22u l=0.5u
X44 vss.t270 a_33552_5176.t22 a_n132_24072.t37 vss.t123 nfet_05v0 ad=0.2132p pd=1.34u as=0.2132p ps=1.34u w=0.82u l=0.6u
X45 vss.t374 dac_code[7].t18 a_33552_5556.t11 vss.t373 nfet_05v0 ad=0.2132p pd=1.34u as=0.2132p ps=1.34u w=0.82u l=0.6u
X46 a_n132_24072.t10 a_33552_5176.t49 vdd.t43 vdd.t42 pfet_05v0 ad=0.3782p pd=1.84u as=0.3782p ps=1.84u w=1.22u l=0.5u
X47 vss.t349 dac_code[0].t8 a_33552_472.t11 vss.t348 nfet_05v0 ad=0.2132p pd=1.34u as=0.2132p ps=1.34u w=0.82u l=0.6u
X48 vdd.t200 dac_code[6].t16 a_33552_5176.t3 vdd.t199 pfet_05v0 ad=0.3782p pd=1.84u as=0.3782p ps=1.84u w=1.22u l=0.5u
X49 a_n132_14472.t29 a_33552_2040.t31 vss.t82 vss.t81 nfet_05v0 ad=0.2132p pd=1.34u as=0.2132p ps=1.34u w=0.82u l=0.6u
X50 a_n132_21672.t4 a_33552_3988.t35 vdd.t354 vdd.t46 pfet_05v0 ad=0.3782p pd=1.84u as=0.3782p ps=1.84u w=1.22u l=0.5u
X51 a_n132_24072.t28 a_33552_5176.t31 vss.t241 vss.t151 nfet_05v0 ad=0.2132p pd=1.34u as=0.2132p ps=1.34u w=0.82u l=0.6u
X52 a_n132_26472.t40 a_29672_25672# vss.t0 ppolyf_u r_width=2u r_length=0.15m
X53 vss.t150 a_33552_2420.t54 a_n132_16872.t26 vss.t8 nfet_05v0 ad=0.2132p pd=1.34u as=0.2132p ps=1.34u w=0.82u l=0.6u
X54 a_n132_12072.t1 a_33552_852.t39 vdd.t294 vdd.t52 pfet_05v0 ad=0.3782p pd=1.84u as=0.3782p ps=1.84u w=1.22u l=0.5u
X55 a_n132_9672.t5 a_33552_472.t55 vdd.t37 vdd.t36 pfet_05v0 ad=0.3782p pd=1.84u as=0.3782p ps=1.84u w=1.22u l=0.5u
X56 a_33552_2420.t16 dac_code[3].t13 vss.t210 vss.t209 nfet_05v0 ad=0.2132p pd=1.34u as=0.2132p ps=1.34u w=0.82u l=0.6u
X57 a_n132_21672.t36 a_33552_3988.t43 vss.t50 vss.t49 nfet_05v0 ad=0.2132p pd=1.34u as=0.2132p ps=1.34u w=0.82u l=0.6u
X58 vdd.t342 a_33552_5176.t46 a_n132_24072.t13 vdd.t242 pfet_05v0 ad=0.3782p pd=1.84u as=0.3782p ps=1.84u w=1.22u l=0.5u
X59 a_n132_12072.t37 a_33552_852.t43 vss.t161 vss.t93 nfet_05v0 ad=0.2132p pd=1.34u as=0.2132p ps=1.34u w=0.82u l=0.6u
X60 vdd.t285 dac_code[5].t4 a_33552_3988.t5 vdd.t284 pfet_05v0 ad=0.3782p pd=1.84u as=0.3782p ps=1.84u w=1.22u l=0.5u
X61 a_33552_5556.t14 dac_code[7].t15 vss.t380 vss.t379 nfet_05v0 ad=0.2132p pd=1.34u as=0.2132p ps=1.34u w=0.82u l=0.6u
X62 a_n132_9672.t35 a_33552_472.t25 vss.t192 vss.t191 nfet_05v0 ad=0.2132p pd=1.34u as=0.2132p ps=1.34u w=0.82u l=0.6u
X63 vss.t92 a_33552_2040.t28 a_n132_14472.t32 vss.t91 nfet_05v0 ad=0.2132p pd=1.34u as=0.2132p ps=1.34u w=0.82u l=0.6u
X64 vss.t158 a_33552_5176.t28 a_n132_24072.t31 vss.t67 nfet_05v0 ad=0.2132p pd=1.34u as=0.2132p ps=1.34u w=0.82u l=0.6u
X65 a_n132_24072.t4 a_33552_5176.t55 vdd.t161 vdd.t160 pfet_05v0 ad=0.3782p pd=1.84u as=0.3782p ps=1.84u w=1.22u l=0.5u
X66 vss.t220 a_33552_852.t52 a_n132_12072.t28 vss.t83 nfet_05v0 ad=0.2132p pd=1.34u as=0.2132p ps=1.34u w=0.82u l=0.6u
X67 vss.t154 a_33552_3988.t52 a_n132_21672.t27 vss.t153 nfet_05v0 ad=0.2132p pd=1.34u as=0.2132p ps=1.34u w=0.82u l=0.6u
X68 vss.t202 dac_code[3].t10 a_33552_2420.t19 vss.t201 nfet_05v0 ad=0.2132p pd=1.34u as=0.2132p ps=1.34u w=0.82u l=0.6u
X69 a_n132_26472.t34 a_33552_5556.t45 vss.t365 vss.t364 nfet_05v0 ad=0.2132p pd=1.34u as=0.2132p ps=1.34u w=0.82u l=0.6u
X70 a_n132_24072.t22 a_33552_5176.t37 vss.t126 vss.t125 nfet_05v0 ad=0.2132p pd=1.34u as=0.2132p ps=1.34u w=0.82u l=0.6u
X71 a_n132_10472# a_n132_8072# vss.t0 ppolyf_u r_width=2u r_length=0.15m
X72 vdd.t204 dac_code[6].t14 a_33552_5176.t5 vdd.t203 pfet_05v0 ad=0.3782p pd=1.84u as=0.3782p ps=1.84u w=1.22u l=0.5u
X73 a_n132_14472.t23 a_33552_2040.t37 vss.t69 vss.t41 nfet_05v0 ad=0.2132p pd=1.34u as=0.2132p ps=1.34u w=0.82u l=0.6u
X74 a_33552_3988.t8 dac_code[5].t1 vdd.t291 vdd.t290 pfet_05v0 ad=0.3782p pd=1.84u as=0.3782p ps=1.84u w=1.22u l=0.5u
X75 vss.t36 a_33552_3608.t30 a_n132_19272.t30 vss.t35 nfet_05v0 ad=0.2132p pd=1.34u as=0.2132p ps=1.34u w=0.82u l=0.6u
X76 vdd.t145 a_33552_2040.t58 a_n132_14472.t2 vdd.t144 pfet_05v0 ad=0.3782p pd=1.84u as=0.3782p ps=1.84u w=1.22u l=0.5u
X77 a_33552_2420.t10 dac_code[3].t19 vss.t204 vss.t203 nfet_05v0 ad=0.2132p pd=1.34u as=0.3608p ps=2.52u w=0.82u l=0.6u
X78 vss.t240 a_33552_5556.t54 a_n132_26472.t25 vss.t239 nfet_05v0 ad=0.2132p pd=1.34u as=0.2132p ps=1.34u w=0.82u l=0.6u
X79 a_n132_9672.t23 a_33552_472.t37 vss.t21 vss.t20 nfet_05v0 ad=0.2132p pd=1.34u as=0.2132p ps=1.34u w=0.82u l=0.6u
X80 a_n132_16872.t13 a_33552_2420.t27 vdd.t112 vdd.t0 pfet_05v0 ad=0.3782p pd=1.84u as=0.3782p ps=1.84u w=1.22u l=0.5u
X81 vss.t137 a_33552_2420.t40 a_n132_16872.t40 vss.t111 nfet_05v0 ad=0.3608p pd=2.52u as=0.2132p ps=1.34u w=0.82u l=0.6u
X82 a_n132_15272# a_29672_16072# vss.t1 ppolyf_u r_width=2u r_length=0.14836m
X83 vdd.t319 dac_code[1].t4 a_33552_852.t5 vdd.t318 pfet_05v0 ad=0.3782p pd=1.84u as=0.3782p ps=1.84u w=1.22u l=0.5u
X84 a_n132_21672.t18 a_33552_3988.t21 vdd.t237 vdd.t166 pfet_05v0 ad=0.3782p pd=1.84u as=0.3782p ps=1.84u w=1.22u l=0.5u
X85 a_33552_5556.t16 dac_code[7].t13 vss.t384 vss.t383 nfet_05v0 ad=0.2132p pd=1.34u as=0.2132p ps=1.34u w=0.82u l=0.6u
X86 vdd.t337 dac_code[0].t10 a_33552_472.t9 vdd.t324 pfet_05v0 ad=0.3782p pd=1.84u as=0.3782p ps=1.84u w=1.22u l=0.5u
X87 a_33552_2040.t2 dac_code[2].t17 vdd.t256 vdd.t219 pfet_05v0 ad=0.3782p pd=1.84u as=0.3782p ps=1.84u w=1.22u l=0.5u
X88 a_33552_5176.t8 dac_code[6].t11 vdd.t210 vdd.t209 pfet_05v0 ad=0.3782p pd=1.84u as=0.3782p ps=1.84u w=1.22u l=0.5u
X89 vss.t313 dac_code[4].t8 a_33552_3608.t11 vss.t205 nfet_05v0 ad=0.2132p pd=1.34u as=0.2132p ps=1.34u w=0.82u l=0.6u
X90 a_n132_16872.t31 a_33552_2420.t49 vss.t63 vss.t33 nfet_05v0 ad=0.2132p pd=1.34u as=0.2132p ps=1.34u w=0.82u l=0.6u
X91 a_n132_12072.t13 a_33552_852.t27 vdd.t71 vdd.t70 pfet_05v0 ad=0.3782p pd=1.84u as=0.3782p ps=1.84u w=1.22u l=0.5u
X92 a_n132_9672.t17 a_33552_472.t43 vdd.t171 vdd.t102 pfet_05v0 ad=0.3782p pd=1.84u as=0.3782p ps=1.84u w=1.22u l=0.5u
X93 vdd.t192 a_33552_2420.t24 a_n132_16872.t16 vdd.t6 pfet_05v0 ad=0.3782p pd=1.84u as=0.3782p ps=1.84u w=1.22u l=0.5u
X94 vss.t198 dac_code[3].t16 a_33552_2420.t13 vss.t197 nfet_05v0 ad=0.2132p pd=1.34u as=0.2132p ps=1.34u w=0.82u l=0.6u
X95 a_n132_21672.t0 a_33552_3988.t39 vdd.t338 vdd.t62 pfet_05v0 ad=0.3782p pd=1.84u as=0.3782p ps=1.84u w=1.22u l=0.5u
X96 vss.t390 dac_code[7].t10 a_33552_5556.t19 vss.t389 nfet_05v0 ad=0.2132p pd=1.34u as=0.2132p ps=1.34u w=0.82u l=0.6u
X97 a_n132_24072.t18 a_33552_5176.t41 vdd.t252 vdd.t120 pfet_05v0 ad=0.3782p pd=1.84u as=0.3782p ps=1.84u w=1.22u l=0.5u
X98 a_n132_24072.t36 a_33552_5176.t23 vss.t277 vss.t49 nfet_05v0 ad=0.2132p pd=1.34u as=0.2132p ps=1.34u w=0.82u l=0.6u
X99 vss.t357 dac_code[0].t4 a_33552_472.t15 vss.t356 nfet_05v0 ad=0.2132p pd=1.34u as=0.2132p ps=1.34u w=0.82u l=0.6u
X100 a_n132_14472.t37 a_33552_2040.t23 vss.t94 vss.t93 nfet_05v0 ad=0.2132p pd=1.34u as=0.2132p ps=1.34u w=0.82u l=0.6u
X101 a_33552_3608.t14 dac_code[4].t5 vss.t316 vss.t207 nfet_05v0 ad=0.2132p pd=1.34u as=0.2132p ps=1.34u w=0.82u l=0.6u
X102 vss.t48 a_33552_2420.t46 a_n132_16872.t34 vss.t47 nfet_05v0 ad=0.2132p pd=1.34u as=0.2132p ps=1.34u w=0.82u l=0.6u
X103 a_n132_21672.t32 a_33552_3988.t47 vss.t66 vss.t65 nfet_05v0 ad=0.2132p pd=1.34u as=0.2132p ps=1.34u w=0.82u l=0.6u
X104 a_33552_5556.t10 dac_code[7].t19 vss.t372 vss.t371 nfet_05v0 ad=0.2132p pd=1.34u as=0.3608p ps=2.52u w=0.82u l=0.6u
X105 a_n132_12072.t33 a_33552_852.t47 vss.t221 vss.t89 nfet_05v0 ad=0.2132p pd=1.34u as=0.2132p ps=1.34u w=0.82u l=0.6u
X106 vss.t392 a_33552_5556.t40 a_n132_26472.t39 vss.t391 nfet_05v0 ad=0.3608p pd=2.52u as=0.2132p ps=1.34u w=0.82u l=0.6u
X107 a_n132_16872.t25 a_33552_2420.t55 vss.t135 vss.t10 nfet_05v0 ad=0.2132p pd=1.34u as=0.2132p ps=1.34u w=0.82u l=0.6u
X108 vdd.t31 a_33552_3608.t58 a_n132_19272.t2 vdd.t30 pfet_05v0 ad=0.3782p pd=1.84u as=0.3782p ps=1.84u w=1.22u l=0.5u
X109 vdd.t156 a_33552_472.t40 a_n132_9672.t20 vdd.t78 pfet_05v0 ad=0.5368p pd=3.32u as=0.3782p ps=1.84u w=1.22u l=0.5u
X110 vss.t84 a_33552_2040.t32 a_n132_14472.t28 vss.t83 nfet_05v0 ad=0.2132p pd=1.34u as=0.2132p ps=1.34u w=0.82u l=0.6u
X111 vdd.t355 a_33552_3988.t36 a_n132_21672.t3 vdd.t48 pfet_05v0 ad=0.3782p pd=1.84u as=0.3782p ps=1.84u w=1.22u l=0.5u
X112 vss.t242 a_33552_5176.t32 a_n132_24072.t27 vss.t153 nfet_05v0 ad=0.2132p pd=1.34u as=0.2132p ps=1.34u w=0.82u l=0.6u
X113 a_n132_24072.t0 a_33552_5176.t59 vdd.t115 vdd.t114 pfet_05v0 ad=0.3782p pd=1.84u as=0.3782p ps=1.84u w=1.22u l=0.5u
X114 a_n132_19272.t35 a_33552_3608.t25 vss.t57 vss.t45 nfet_05v0 ad=0.2132p pd=1.34u as=0.2132p ps=1.34u w=0.82u l=0.6u
X115 a_33552_852.t0 dac_code[1].t9 vdd.t309 vdd.t308 pfet_05v0 ad=0.3782p pd=1.84u as=0.5368p ps=3.32u w=1.22u l=0.5u
X116 a_33552_472.t4 dac_code[0].t15 vdd.t332 vdd.t316 pfet_05v0 ad=0.3782p pd=1.84u as=0.3782p ps=1.84u w=1.22u l=0.5u
X117 a_n132_9672.t39 a_33552_472.t21 vss.t329 vss.t328 nfet_05v0 ad=0.2132p pd=1.34u as=0.2132p ps=1.34u w=0.82u l=0.6u
X118 vss.t200 dac_code[3].t14 a_33552_2420.t15 vss.t199 nfet_05v0 ad=0.2132p pd=1.34u as=0.2132p ps=1.34u w=0.82u l=0.6u
X119 a_n132_26472.t30 a_33552_5556.t49 vss.t228 vss.t227 nfet_05v0 ad=0.2132p pd=1.34u as=0.2132p ps=1.34u w=0.82u l=0.6u
X120 a_33552_3608.t2 dac_code[4].t17 vdd.t300 vdd.t278 pfet_05v0 ad=0.3782p pd=1.84u as=0.3782p ps=1.84u w=1.22u l=0.5u
X121 vss.t162 a_33552_852.t44 a_n132_12072.t36 vss.t95 nfet_05v0 ad=0.2132p pd=1.34u as=0.2132p ps=1.34u w=0.82u l=0.6u
X122 vss.t52 a_33552_3988.t44 a_n132_21672.t35 vss.t51 nfet_05v0 ad=0.2132p pd=1.34u as=0.2132p ps=1.34u w=0.82u l=0.6u
X123 vss.t378 dac_code[7].t16 a_33552_5556.t13 vss.t377 nfet_05v0 ad=0.2132p pd=1.34u as=0.2132p ps=1.34u w=0.82u l=0.6u
X124 vdd.t265 a_33552_852.t32 a_n132_12072.t8 vdd.t64 pfet_05v0 ad=0.3782p pd=1.84u as=0.3782p ps=1.84u w=1.22u l=0.5u
X125 vss.t9 a_33552_3608.t34 a_n132_19272.t26 vss.t8 nfet_05v0 ad=0.2132p pd=1.34u as=0.2132p ps=1.34u w=0.82u l=0.6u
X126 vdd.t359 a_33552_5556.t38 a_n132_26472.t1 vdd.t176 pfet_05v0 ad=0.3782p pd=1.84u as=0.3782p ps=1.84u w=1.22u l=0.5u
X127 vdd.t163 a_33552_5176.t56 a_n132_24072.t3 vdd.t162 pfet_05v0 ad=0.3782p pd=1.84u as=0.3782p ps=1.84u w=1.22u l=0.5u
X128 vdd.t84 a_33552_472.t48 a_n132_9672.t12 vdd.t72 pfet_05v0 ad=0.3782p pd=1.84u as=0.3782p ps=1.84u w=1.22u l=0.5u
X129 a_n132_21672.t6 a_33552_3988.t33 vdd.t235 vdd.t185 pfet_05v0 ad=0.3782p pd=1.84u as=0.3782p ps=1.84u w=1.22u l=0.5u
X130 a_33552_3608.t16 dac_code[4].t3 vss.t318 vss.t209 nfet_05v0 ad=0.2132p pd=1.34u as=0.2132p ps=1.34u w=0.82u l=0.6u
X131 vdd.t179 a_33552_2040.t50 a_n132_14472.t10 vdd.t40 pfet_05v0 ad=0.3782p pd=1.84u as=0.3782p ps=1.84u w=1.22u l=0.5u
X132 a_33552_2420.t18 dac_code[3].t11 vss.t212 vss.t211 nfet_05v0 ad=0.2132p pd=1.34u as=0.2132p ps=1.34u w=0.82u l=0.6u
X133 vss.t367 a_33552_5556.t46 a_n132_26472.t33 vss.t366 nfet_05v0 ad=0.2132p pd=1.34u as=0.2132p ps=1.34u w=0.82u l=0.6u
X134 a_33552_5556.t2 dac_code[7].t7 vdd.t345 vdd.t197 pfet_05v0 ad=0.3782p pd=1.84u as=0.3782p ps=1.84u w=1.22u l=0.5u
X135 a_n132_22472# a_n132_20072# vss.t0 ppolyf_u r_width=2u r_length=0.15m
X136 vdd.t289 dac_code[5].t2 a_33552_3988.t7 vdd.t288 pfet_05v0 ad=0.3782p pd=1.84u as=0.3782p ps=1.84u w=1.22u l=0.5u
X137 vss.t351 dac_code[0].t6 a_33552_472.t13 vss.t350 nfet_05v0 ad=0.2132p pd=1.34u as=0.2132p ps=1.34u w=0.82u l=0.6u
X138 a_n132_26472.t24 a_33552_5556.t55 vss.t224 vss.t223 nfet_05v0 ad=0.2132p pd=1.34u as=0.2132p ps=1.34u w=0.82u l=0.6u
X139 a_n132_24072.t6 a_33552_5176.t53 vdd.t59 vdd.t58 pfet_05v0 ad=0.3782p pd=1.84u as=0.3782p ps=1.84u w=1.22u l=0.5u
X140 a_n132_12072.t11 a_33552_852.t29 vdd.t295 vdd.t85 pfet_05v0 ad=0.3782p pd=1.84u as=0.3782p ps=1.84u w=1.22u l=0.5u
X141 a_33552_472.t2 dac_code[0].t17 vdd.t330 vdd.t312 pfet_05v0 ad=0.3782p pd=1.84u as=0.3782p ps=1.84u w=1.22u l=0.5u
X142 a_n132_9672.t15 a_33552_472.t45 vdd.t183 vdd.t126 pfet_05v0 ad=0.3782p pd=1.84u as=0.3782p ps=1.84u w=1.22u l=0.5u
X143 vss.t321 dac_code[4].t0 a_33552_3608.t19 vss.t201 nfet_05v0 ad=0.2132p pd=1.34u as=0.2132p ps=1.34u w=0.82u l=0.6u
X144 vdd.t255 dac_code[2].t18 a_33552_2040.t1 vdd.t217 pfet_05v0 ad=0.3782p pd=1.84u as=0.3782p ps=1.84u w=1.22u l=0.5u
X145 a_n132_16872.t39 a_33552_2420.t41 vss.t293 vss.t77 nfet_05v0 ad=0.2132p pd=1.34u as=0.2132p ps=1.34u w=0.82u l=0.6u
X146 vdd.t238 a_33552_3988.t22 a_n132_21672.t17 vdd.t168 pfet_05v0 ad=0.3782p pd=1.84u as=0.3782p ps=1.84u w=1.22u l=0.5u
X147 vss.t382 dac_code[7].t14 a_33552_5556.t15 vss.t381 nfet_05v0 ad=0.2132p pd=1.34u as=0.2132p ps=1.34u w=0.82u l=0.6u
X148 a_n132_17672# a_n132_15272# vss.t0 ppolyf_u r_width=2u r_length=0.15m
X149 vdd.t208 dac_code[6].t12 a_33552_5176.t7 vdd.t207 pfet_05v0 ad=0.3782p pd=1.84u as=0.3782p ps=1.84u w=1.22u l=0.5u
X150 a_n132_24072.t32 a_33552_5176.t27 vss.t157 vss.t65 nfet_05v0 ad=0.2132p pd=1.34u as=0.2132p ps=1.34u w=0.82u l=0.6u
X151 a_n132_14472.t33 a_33552_2040.t27 vss.t90 vss.t89 nfet_05v0 ad=0.2132p pd=1.34u as=0.2132p ps=1.34u w=0.82u l=0.6u
X152 a_n132_21672.t8 a_33552_3988.t31 vdd.t94 vdd.t90 pfet_05v0 ad=0.3782p pd=1.84u as=0.3782p ps=1.84u w=1.22u l=0.5u
X153 a_33552_3608.t10 dac_code[4].t9 vss.t312 vss.t203 nfet_05v0 ad=0.2132p pd=1.34u as=0.3608p ps=2.52u w=0.82u l=0.6u
X154 vss.t112 a_33552_3608.t20 a_n132_19272.t40 vss.t111 nfet_05v0 ad=0.3608p pd=2.52u as=0.2132p ps=1.34u w=0.82u l=0.6u
X155 a_n132_12072.t3 a_33552_852.t37 vdd.t68 vdd.t18 pfet_05v0 ad=0.3782p pd=1.84u as=0.3782p ps=1.84u w=1.22u l=0.5u
X156 a_n132_9672.t7 a_33552_472.t53 vdd.t67 vdd.t66 pfet_05v0 ad=0.3782p pd=1.84u as=0.3782p ps=1.84u w=1.22u l=0.5u
X157 a_33552_2040.t4 dac_code[2].t15 vdd.t258 vdd.t223 pfet_05v0 ad=0.3782p pd=1.84u as=0.3782p ps=1.84u w=1.22u l=0.5u
X158 a_n132_16872.t21 a_33552_2420.t59 vss.t267 vss.t155 nfet_05v0 ad=0.2132p pd=1.34u as=0.2132p ps=1.34u w=0.82u l=0.6u
X159 a_33552_472.t12 dac_code[0].t7 vss.t345 vss.t344 nfet_05v0 ad=0.2132p pd=1.34u as=0.2132p ps=1.34u w=0.82u l=0.6u
X160 a_33552_5556.t18 dac_code[7].t11 vss.t388 vss.t387 nfet_05v0 ad=0.2132p pd=1.34u as=0.2132p ps=1.34u w=0.82u l=0.6u
X161 vdd.t253 a_33552_5176.t42 a_n132_24072.t17 vdd.t122 pfet_05v0 ad=0.3782p pd=1.84u as=0.3782p ps=1.84u w=1.22u l=0.5u
X162 a_n132_19272.t31 a_33552_3608.t29 vss.t34 vss.t33 nfet_05v0 ad=0.2132p pd=1.34u as=0.2132p ps=1.34u w=0.82u l=0.6u
X163 vdd.t133 a_33552_3608.t50 a_n132_19272.t10 vdd.t132 pfet_05v0 ad=0.3782p pd=1.84u as=0.3782p ps=1.84u w=1.22u l=0.5u
X164 vss.t96 a_33552_2040.t24 a_n132_14472.t36 vss.t95 nfet_05v0 ad=0.2132p pd=1.34u as=0.2132p ps=1.34u w=0.82u l=0.6u
X165 vdd.t271 a_33552_3988.t28 a_n132_21672.t11 vdd.t148 pfet_05v0 ad=0.3782p pd=1.84u as=0.3782p ps=1.84u w=1.22u l=0.5u
X166 vss.t278 a_33552_5176.t24 a_n132_24072.t35 vss.t51 nfet_05v0 ad=0.2132p pd=1.34u as=0.2132p ps=1.34u w=0.82u l=0.6u
X167 a_n132_24072.t8 a_33552_5176.t51 vdd.t25 vdd.t24 pfet_05v0 ad=0.3782p pd=1.84u as=0.3782p ps=1.84u w=1.22u l=0.5u
X168 vss.t315 dac_code[4].t6 a_33552_3608.t13 vss.t197 nfet_05v0 ad=0.2132p pd=1.34u as=0.2132p ps=1.34u w=0.82u l=0.6u
X169 a_n132_12072.t0 a_29672_11272# vss.t0 ppolyf_u r_width=2u r_length=0.15m
X170 a_n132_14472.t15 a_33552_2040.t45 vdd.t9 vdd.t8 pfet_05v0 ad=0.3782p pd=1.84u as=0.3782p ps=1.84u w=1.22u l=0.5u
X171 a_n132_26472.t38 a_33552_5556.t41 vss.t130 vss.t129 nfet_05v0 ad=0.2132p pd=1.34u as=0.2132p ps=1.34u w=0.82u l=0.6u
X172 vdd.t101 a_33552_852.t34 a_n132_12072.t6 vdd.t34 pfet_05v0 ad=0.3782p pd=1.84u as=0.3782p ps=1.84u w=1.22u l=0.5u
X173 vss.t136 a_33552_2420.t56 a_n132_16872.t24 vss.t12 nfet_05v0 ad=0.2132p pd=1.34u as=0.2132p ps=1.34u w=0.82u l=0.6u
X174 vdd.t81 a_33552_472.t50 a_n132_9672.t10 vdd.t80 pfet_05v0 ad=0.3782p pd=1.84u as=0.3782p ps=1.84u w=1.22u l=0.5u
X175 a_n132_21672.t2 a_33552_3988.t37 vdd.t268 vdd.t28 pfet_05v0 ad=0.3782p pd=1.84u as=0.3782p ps=1.84u w=1.22u l=0.5u
X176 vdd.t107 a_33552_5556.t30 a_n132_26472.t9 vdd.t44 pfet_05v0 ad=0.3782p pd=1.84u as=0.3782p ps=1.84u w=1.22u l=0.5u
X177 vss.t323 a_33552_472.t30 a_n132_9672.t30 vss.t322 nfet_05v0 ad=0.2132p pd=1.34u as=0.2132p ps=1.34u w=0.82u l=0.6u
X178 vss.t58 a_33552_3608.t26 a_n132_19272.t34 vss.t47 nfet_05v0 ad=0.2132p pd=1.34u as=0.2132p ps=1.34u w=0.82u l=0.6u
X179 vdd.t299 dac_code[4].t18 a_33552_3608.t1 vdd.t276 pfet_05v0 ad=0.3782p pd=1.84u as=0.3782p ps=1.84u w=1.22u l=0.5u
X180 a_n132_9672.t37 a_33552_472.t23 vss.t120 vss.t119 nfet_05v0 ad=0.2132p pd=1.34u as=0.2132p ps=1.34u w=0.82u l=0.6u
X181 vdd.t99 a_33552_5176.t48 a_n132_24072.t11 vdd.t98 pfet_05v0 ad=0.3782p pd=1.84u as=0.3782p ps=1.84u w=1.22u l=0.5u
X182 vdd.t151 a_33552_2040.t54 a_n132_14472.t6 vdd.t56 pfet_05v0 ad=0.3782p pd=1.84u as=0.3782p ps=1.84u w=1.22u l=0.5u
X183 a_n132_19272.t25 a_33552_3608.t35 vss.t11 vss.t10 nfet_05v0 ad=0.2132p pd=1.34u as=0.2132p ps=1.34u w=0.82u l=0.6u
X184 a_33552_2040.t6 dac_code[2].t13 vdd.t260 vdd.t227 pfet_05v0 ad=0.3782p pd=1.84u as=0.3782p ps=1.84u w=1.22u l=0.5u
X185 vdd.t323 dac_code[1].t2 a_33552_852.t7 vdd.t322 pfet_05v0 ad=0.3782p pd=1.84u as=0.3782p ps=1.84u w=1.22u l=0.5u
X186 a_n132_16872.t27 a_33552_2420.t53 vss.t149 vss.t6 nfet_05v0 ad=0.2132p pd=1.34u as=0.2132p ps=1.34u w=0.82u l=0.6u
X187 a_n132_26472.t20 a_33552_5556.t59 vss.t236 vss.t235 nfet_05v0 ad=0.2132p pd=1.34u as=0.2132p ps=1.34u w=0.82u l=0.6u
X188 a_n132_24072.t2 a_33552_5176.t57 vdd.t175 vdd.t174 pfet_05v0 ad=0.3782p pd=1.84u as=0.3782p ps=1.84u w=1.22u l=0.5u
X189 vdd.t344 dac_code[7].t8 a_33552_5556.t1 vdd.t195 pfet_05v0 ad=0.3782p pd=1.84u as=0.3782p ps=1.84u w=1.22u l=0.5u
X190 vss.t317 dac_code[4].t4 a_33552_3608.t15 vss.t199 nfet_05v0 ad=0.2132p pd=1.34u as=0.2132p ps=1.34u w=0.82u l=0.6u
X191 a_33552_3608.t4 dac_code[4].t15 vdd.t302 vdd.t282 pfet_05v0 ad=0.3782p pd=1.84u as=0.3782p ps=1.84u w=1.22u l=0.5u
X192 vss.t361 dac_code[0].t2 a_33552_472.t17 vss.t360 nfet_05v0 ad=0.2132p pd=1.34u as=0.2132p ps=1.34u w=0.82u l=0.6u
X193 vss.t194 dac_code[3].t12 a_33552_2420.t17 vss.t193 nfet_05v0 ad=0.2132p pd=1.34u as=0.2132p ps=1.34u w=0.82u l=0.6u
X194 vdd.t263 dac_code[2].t10 a_33552_2040.t9 vdd.t233 pfet_05v0 ad=0.3782p pd=1.84u as=0.3782p ps=1.84u w=1.22u l=0.5u
X195 vss.t226 a_33552_5556.t56 a_n132_26472.t23 vss.t225 nfet_05v0 ad=0.2132p pd=1.34u as=0.2132p ps=1.34u w=0.82u l=0.6u
X196 a_n132_19272.t15 a_33552_3608.t45 vdd.t139 vdd.t138 pfet_05v0 ad=0.3782p pd=1.84u as=0.3782p ps=1.84u w=1.22u l=0.5u
X197 a_n132_21672.t16 a_33552_3988.t23 vdd.t356 vdd.t152 pfet_05v0 ad=0.3782p pd=1.84u as=0.3782p ps=1.84u w=1.22u l=0.5u
X198 a_33552_5556.t4 dac_code[7].t5 vdd.t347 vdd.t201 pfet_05v0 ad=0.3782p pd=1.84u as=0.3782p ps=1.84u w=1.22u l=0.5u
X199 a_33552_3608.t18 dac_code[4].t1 vss.t320 vss.t211 nfet_05v0 ad=0.2132p pd=1.34u as=0.2132p ps=1.34u w=0.82u l=0.6u
X200 vss.t294 a_33552_2420.t42 a_n132_16872.t38 vss.t79 nfet_05v0 ad=0.2132p pd=1.34u as=0.2132p ps=1.34u w=0.82u l=0.6u
X201 a_33552_2040.t0 dac_code[2].t19 vdd.t254 vdd.t215 pfet_05v0 ad=0.3782p pd=1.84u as=0.5368p ps=3.32u w=1.22u l=0.5u
X202 vdd.t33 a_33552_2040.t40 a_n132_14472.t20 vdd.t32 pfet_05v0 ad=0.5368p pd=3.32u as=0.3782p ps=1.84u w=1.22u l=0.5u
X203 a_n132_16872.t29 a_33552_2420.t51 vss.t143 vss.t14 nfet_05v0 ad=0.2132p pd=1.34u as=0.2132p ps=1.34u w=0.82u l=0.6u
X204 vdd.t77 a_33552_852.t22 a_n132_12072.t18 vdd.t76 pfet_05v0 ad=0.3782p pd=1.84u as=0.3782p ps=1.84u w=1.22u l=0.5u
X205 vdd.t188 a_33552_3608.t54 a_n132_19272.t6 vdd.t187 pfet_05v0 ad=0.3782p pd=1.84u as=0.3782p ps=1.84u w=1.22u l=0.5u
X206 vdd.t95 a_33552_3988.t32 a_n132_21672.t7 vdd.t92 pfet_05v0 ad=0.3782p pd=1.84u as=0.3782p ps=1.84u w=1.22u l=0.5u
X207 a_n132_26472.t26 a_33552_5556.t53 vss.t238 vss.t237 nfet_05v0 ad=0.2132p pd=1.34u as=0.2132p ps=1.34u w=0.82u l=0.6u
X208 a_33552_472.t6 dac_code[0].t13 vdd.t334 vdd.t320 pfet_05v0 ad=0.3782p pd=1.84u as=0.3782p ps=1.84u w=1.22u l=0.5u
X209 a_n132_26472.t14 a_33552_5556.t25 vdd.t241 vdd.t240 pfet_05v0 ad=0.3782p pd=1.84u as=0.3782p ps=1.84u w=1.22u l=0.5u
X210 a_n132_19272.t39 a_33552_3608.t21 vss.t78 vss.t77 nfet_05v0 ad=0.2132p pd=1.34u as=0.2132p ps=1.34u w=0.82u l=0.6u
X211 a_33552_3608.t6 dac_code[4].t13 vdd.t304 vdd.t286 pfet_05v0 ad=0.3782p pd=1.84u as=0.3782p ps=1.84u w=1.22u l=0.5u
X212 a_33552_472.t10 dac_code[0].t9 vss.t347 vss.t346 nfet_05v0 ad=0.2132p pd=1.34u as=0.3608p ps=2.52u w=0.82u l=0.6u
X213 a_n132_24072.t16 a_33552_5176.t43 vdd.t272 vdd.t248 pfet_05v0 ad=0.3782p pd=1.84u as=0.3782p ps=1.84u w=1.22u l=0.5u
X214 a_n132_14472.t11 a_33552_2040.t49 vdd.t178 vdd.t38 pfet_05v0 ad=0.3782p pd=1.84u as=0.3782p ps=1.84u w=1.22u l=0.5u
X215 vdd.t257 dac_code[2].t16 a_33552_2040.t3 vdd.t221 pfet_05v0 ad=0.3782p pd=1.84u as=0.3782p ps=1.84u w=1.22u l=0.5u
X216 vss.t386 dac_code[7].t12 a_33552_5556.t17 vss.t385 nfet_05v0 ad=0.2132p pd=1.34u as=0.2132p ps=1.34u w=0.82u l=0.6u
X217 vdd.t245 a_33552_5556.t34 a_n132_26472.t5 vdd.t60 pfet_05v0 ad=0.3782p pd=1.84u as=0.3782p ps=1.84u w=1.22u l=0.5u
X218 vss.t27 a_33552_2420.t48 a_n132_16872.t32 vss.t26 nfet_05v0 ad=0.2132p pd=1.34u as=0.2132p ps=1.34u w=0.82u l=0.6u
X219 vdd.t27 a_33552_5176.t52 a_n132_24072.t7 vdd.t26 pfet_05v0 ad=0.3782p pd=1.84u as=0.3782p ps=1.84u w=1.22u l=0.5u
X220 a_n132_24072.t40 a_29672_23272# vss.t0 ppolyf_u r_width=2u r_length=0.15m
X221 a_33552_5556.t6 dac_code[7].t3 vdd.t349 vdd.t205 pfet_05v0 ad=0.3782p pd=1.84u as=0.3782p ps=1.84u w=1.22u l=0.5u
X222 a_n132_19272.t21 a_33552_3608.t39 vss.t156 vss.t155 nfet_05v0 ad=0.2132p pd=1.34u as=0.2132p ps=1.34u w=0.82u l=0.6u
X223 vdd.t307 dac_code[4].t10 a_33552_3608.t9 vdd.t292 pfet_05v0 ad=0.3782p pd=1.84u as=0.3782p ps=1.84u w=1.22u l=0.5u
X224 a_n132_12872# a_29672_13672# vss.t1 ppolyf_u r_width=2u r_length=0.14836m
X225 vdd.t11 a_33552_2040.t46 a_n132_14472.t14 vdd.t10 pfet_05v0 ad=0.3782p pd=1.84u as=0.3782p ps=1.84u w=1.22u l=0.5u
X226 vss.t288 a_33552_472.t26 a_n132_9672.t34 vss.t287 nfet_05v0 ad=0.2132p pd=1.34u as=0.2132p ps=1.34u w=0.82u l=0.6u
X227 a_n132_16872.t23 a_33552_2420.t57 vss.t308 vss.t2 nfet_05v0 ad=0.2132p pd=1.34u as=0.2132p ps=1.34u w=0.82u l=0.6u
X228 vss.t132 a_33552_5556.t42 a_n132_26472.t37 vss.t131 nfet_05v0 ad=0.2132p pd=1.34u as=0.2132p ps=1.34u w=0.82u l=0.6u
X229 a_n132_14472.t5 a_33552_2040.t55 vdd.t135 vdd.t134 pfet_05v0 ad=0.3782p pd=1.84u as=0.3782p ps=1.84u w=1.22u l=0.5u
X230 a_n132_26472.t28 a_33552_5556.t51 vss.t280 vss.t279 nfet_05v0 ad=0.2132p pd=1.34u as=0.2132p ps=1.34u w=0.82u l=0.6u
X231 a_33552_3608.t0 dac_code[4].t19 vdd.t298 vdd.t274 pfet_05v0 ad=0.3782p pd=1.84u as=0.5368p ps=3.32u w=1.22u l=0.5u
X232 vdd.t181 a_33552_3608.t40 a_n132_19272.t20 vdd.t180 pfet_05v0 ad=0.5368p pd=3.32u as=0.3782p ps=1.84u w=1.22u l=0.5u
X233 a_n132_19272.t0 a_29672_18472# vss.t0 ppolyf_u r_width=2u r_length=0.15m
X234 vdd.t351 dac_code[7].t0 a_33552_5556.t9 vdd.t211 pfet_05v0 ad=0.3782p pd=1.84u as=0.3782p ps=1.84u w=1.22u l=0.5u
X235 vss.t13 a_33552_3608.t36 a_n132_19272.t24 vss.t12 nfet_05v0 ad=0.2132p pd=1.34u as=0.2132p ps=1.34u w=0.82u l=0.6u
X236 vdd.t329 dac_code[0].t18 a_33552_472.t1 vdd.t310 pfet_05v0 ad=0.3782p pd=1.84u as=0.3782p ps=1.84u w=1.22u l=0.5u
X237 vdd.t259 dac_code[2].t14 a_33552_2040.t5 vdd.t225 pfet_05v0 ad=0.3782p pd=1.84u as=0.3782p ps=1.84u w=1.22u l=0.5u
X238 a_n132_19272.t11 a_33552_3608.t49 vdd.t131 vdd.t130 pfet_05v0 ad=0.3782p pd=1.84u as=0.3782p ps=1.84u w=1.22u l=0.5u
X239 a_n132_21672.t12 a_33552_3988.t27 vdd.t270 vdd.t146 pfet_05v0 ad=0.3782p pd=1.84u as=0.3782p ps=1.84u w=1.22u l=0.5u
X240 vss.t286 a_33552_5556.t48 a_n132_26472.t31 vss.t285 nfet_05v0 ad=0.2132p pd=1.34u as=0.2132p ps=1.34u w=0.82u l=0.6u
X241 a_33552_5556.t0 dac_code[7].t9 vdd.t343 vdd.t193 pfet_05v0 ad=0.3782p pd=1.84u as=0.5368p ps=3.32u w=1.22u l=0.5u
X242 a_n132_9672.t9 a_33552_472.t51 vdd.t83 vdd.t82 pfet_05v0 ad=0.3782p pd=1.84u as=0.3782p ps=1.84u w=1.22u l=0.5u
X243 vdd.t301 dac_code[4].t16 a_33552_3608.t3 vdd.t280 pfet_05v0 ad=0.3782p pd=1.84u as=0.3782p ps=1.84u w=1.22u l=0.5u
X244 vdd.t109 a_33552_5556.t20 a_n132_26472.t19 vdd.t108 pfet_05v0 ad=0.5368p pd=3.32u as=0.3782p ps=1.84u w=1.22u l=0.5u
X245 a_n132_19272.t27 a_33552_3608.t33 vss.t7 vss.t6 nfet_05v0 ad=0.2132p pd=1.34u as=0.2132p ps=1.34u w=0.82u l=0.6u
X246 a_33552_2040.t8 dac_code[2].t11 vdd.t262 vdd.t231 pfet_05v0 ad=0.3782p pd=1.84u as=0.3782p ps=1.84u w=1.22u l=0.5u
X247 a_n132_26472.t22 a_33552_5556.t57 vss.t232 vss.t231 nfet_05v0 ad=0.2132p pd=1.34u as=0.2132p ps=1.34u w=0.82u l=0.6u
X248 a_n132_16872.t37 a_33552_2420.t43 vss.t291 vss.t107 nfet_05v0 ad=0.2132p pd=1.34u as=0.2132p ps=1.34u w=0.82u l=0.6u
X249 a_n132_26472.t10 a_33552_5556.t29 vdd.t106 vdd.t42 pfet_05v0 ad=0.3782p pd=1.84u as=0.3782p ps=1.84u w=1.22u l=0.5u
X250 vdd.t141 a_33552_3608.t46 a_n132_19272.t14 vdd.t140 pfet_05v0 ad=0.3782p pd=1.84u as=0.3782p ps=1.84u w=1.22u l=0.5u
X251 vdd.t357 a_33552_3988.t24 a_n132_21672.t15 vdd.t154 pfet_05v0 ad=0.3782p pd=1.84u as=0.3782p ps=1.84u w=1.22u l=0.5u
X252 vdd.t346 dac_code[7].t6 a_33552_5556.t3 vdd.t199 pfet_05v0 ad=0.3782p pd=1.84u as=0.3782p ps=1.84u w=1.22u l=0.5u
X253 a_n132_24072.t12 a_33552_5176.t47 vdd.t97 vdd.t96 pfet_05v0 ad=0.3782p pd=1.84u as=0.3782p ps=1.84u w=1.22u l=0.5u
X254 vss.t319 dac_code[4].t2 a_33552_3608.t17 vss.t193 nfet_05v0 ad=0.2132p pd=1.34u as=0.2132p ps=1.34u w=0.82u l=0.6u
X255 a_n132_19272.t5 a_33552_3608.t55 vdd.t47 vdd.t46 pfet_05v0 ad=0.3782p pd=1.84u as=0.3782p ps=1.84u w=1.22u l=0.5u
X256 a_n132_14472.t19 a_33552_2040.t41 vdd.t13 vdd.t12 pfet_05v0 ad=0.3782p pd=1.84u as=0.3782p ps=1.84u w=1.22u l=0.5u
X257 vss.t144 a_33552_2420.t52 a_n132_16872.t28 vss.t16 nfet_05v0 ad=0.2132p pd=1.34u as=0.2132p ps=1.34u w=0.82u l=0.6u
X258 a_n132_12072.t5 a_33552_852.t35 vdd.t124 vdd.t36 pfet_05v0 ad=0.3782p pd=1.84u as=0.3782p ps=1.84u w=1.22u l=0.5u
X259 vdd.t243 a_33552_5556.t26 a_n132_26472.t13 vdd.t242 pfet_05v0 ad=0.3782p pd=1.84u as=0.3782p ps=1.84u w=1.22u l=0.5u
X260 vss.t80 a_33552_3608.t22 a_n132_19272.t38 vss.t79 nfet_05v0 ad=0.2132p pd=1.34u as=0.2132p ps=1.34u w=0.82u l=0.6u
X261 vdd.t303 dac_code[4].t14 a_33552_3608.t5 vdd.t284 pfet_05v0 ad=0.3782p pd=1.84u as=0.3782p ps=1.84u w=1.22u l=0.5u
X262 vdd.t273 a_33552_5176.t44 a_n132_24072.t15 vdd.t250 pfet_05v0 ad=0.3782p pd=1.84u as=0.3782p ps=1.84u w=1.22u l=0.5u
X263 a_n132_26472.t4 a_33552_5556.t35 vdd.t246 vdd.t160 pfet_05v0 ad=0.3782p pd=1.84u as=0.3782p ps=1.84u w=1.22u l=0.5u
X264 a_n132_19272.t29 a_33552_3608.t31 vss.t15 vss.t14 nfet_05v0 ad=0.2132p pd=1.34u as=0.2132p ps=1.34u w=0.82u l=0.6u
X265 vdd.t17 a_33552_472.t56 a_n132_9672.t4 vdd.t16 pfet_05v0 ad=0.3782p pd=1.84u as=0.3782p ps=1.84u w=1.22u l=0.5u
X266 a_n132_14472.t1 a_33552_2040.t59 vdd.t129 vdd.t110 pfet_05v0 ad=0.3782p pd=1.84u as=0.3782p ps=1.84u w=1.22u l=0.5u
X267 vss.t272 a_33552_472.t28 a_n132_9672.t32 vss.t271 nfet_05v0 ad=0.2132p pd=1.34u as=0.2132p ps=1.34u w=0.82u l=0.6u
X268 vss.t118 a_33552_472.t22 a_n132_9672.t38 vss.t117 nfet_05v0 ad=0.2132p pd=1.34u as=0.2132p ps=1.34u w=0.82u l=0.6u
X269 a_n132_26472.t36 a_33552_5556.t43 vss.t164 vss.t163 nfet_05v0 ad=0.2132p pd=1.34u as=0.2132p ps=1.34u w=0.82u l=0.6u
X270 vdd.t348 dac_code[7].t4 a_33552_5556.t5 vdd.t203 pfet_05v0 ad=0.3782p pd=1.84u as=0.3782p ps=1.84u w=1.22u l=0.5u
X271 a_33552_3608.t8 dac_code[4].t11 vdd.t306 vdd.t290 pfet_05v0 ad=0.3782p pd=1.84u as=0.3782p ps=1.84u w=1.22u l=0.5u
X272 vout.t1 a_29672_25672# vss.t1 ppolyf_u r_width=2u r_length=0.14836m
X273 vdd.t173 a_33552_2420.t38 a_n132_16872.t2 vdd.t144 pfet_05v0 ad=0.3782p pd=1.84u as=0.3782p ps=1.84u w=1.22u l=0.5u
X274 vss.t72 a_33552_3608.t28 a_n132_19272.t32 vss.t26 nfet_05v0 ad=0.2132p pd=1.34u as=0.2132p ps=1.34u w=0.82u l=0.6u
X275 vdd.t137 a_33552_2040.t56 a_n132_14472.t4 vdd.t136 pfet_05v0 ad=0.3782p pd=1.84u as=0.3782p ps=1.84u w=1.22u l=0.5u
X276 vss.t282 a_33552_5556.t52 a_n132_26472.t27 vss.t281 nfet_05v0 ad=0.2132p pd=1.34u as=0.2132p ps=1.34u w=0.82u l=0.6u
X277 a_n132_8072# a_n132_7272# vss.t0 ppolyf_u r_width=2u r_length=0.15m
X278 a_n132_19272.t19 a_33552_3608.t41 vdd.t167 vdd.t166 pfet_05v0 ad=0.3782p pd=1.84u as=0.3782p ps=1.84u w=1.22u l=0.5u
X279 vdd.t325 dac_code[1].t0 a_33552_852.t9 vdd.t324 pfet_05v0 ad=0.3782p pd=1.84u as=0.3782p ps=1.84u w=1.22u l=0.5u
X280 a_33552_5556.t8 dac_code[7].t1 vdd.t352 vdd.t209 pfet_05v0 ad=0.3782p pd=1.84u as=0.3782p ps=1.84u w=1.22u l=0.5u
X281 a_33552_2420.t2 dac_code[3].t7 vdd.t220 vdd.t219 pfet_05v0 ad=0.3782p pd=1.84u as=0.3782p ps=1.84u w=1.22u l=0.5u
X282 a_n132_19272.t23 a_33552_3608.t37 vss.t3 vss.t2 nfet_05v0 ad=0.2132p pd=1.34u as=0.2132p ps=1.34u w=0.82u l=0.6u
X283 a_n132_20072# a_n132_17672# vss.t0 ppolyf_u r_width=2u r_length=0.15m
X284 a_n132_14472.t7 a_33552_2040.t53 vdd.t150 vdd.t54 pfet_05v0 ad=0.3782p pd=1.84u as=0.3782p ps=1.84u w=1.22u l=0.5u
X285 a_n132_16872.t33 a_33552_2420.t47 vss.t25 vss.t24 nfet_05v0 ad=0.2132p pd=1.34u as=0.2132p ps=1.34u w=0.82u l=0.6u
X286 a_n132_12072.t17 a_33552_852.t23 vdd.t103 vdd.t102 pfet_05v0 ad=0.3782p pd=1.84u as=0.3782p ps=1.84u w=1.22u l=0.5u
X287 a_n132_9672.t25 a_33552_472.t35 vss.t40 vss.t39 nfet_05v0 ad=0.2132p pd=1.34u as=0.2132p ps=1.34u w=0.82u l=0.6u
X288 a_n132_9672.t31 a_33552_472.t29 vss.t274 vss.t273 nfet_05v0 ad=0.2132p pd=1.34u as=0.2132p ps=1.34u w=0.82u l=0.6u
X289 a_33552_472.t8 dac_code[0].t11 vdd.t336 vdd.t326 pfet_05v0 ad=0.3782p pd=1.84u as=0.3782p ps=1.84u w=1.22u l=0.5u
X290 a_n132_26472.t18 a_33552_5556.t21 vdd.t121 vdd.t120 pfet_05v0 ad=0.3782p pd=1.84u as=0.3782p ps=1.84u w=1.22u l=0.5u
X291 a_n132_19272.t1 a_33552_3608.t59 vdd.t63 vdd.t62 pfet_05v0 ad=0.3782p pd=1.84u as=0.3782p ps=1.84u w=1.22u l=0.5u
X292 vdd.t261 dac_code[2].t12 a_33552_2040.t7 vdd.t229 pfet_05v0 ad=0.3782p pd=1.84u as=0.3782p ps=1.84u w=1.22u l=0.5u
X293 vdd.t182 a_33552_472.t44 a_n132_9672.t16 vdd.t104 pfet_05v0 ad=0.3782p pd=1.84u as=0.3782p ps=1.84u w=1.22u l=0.5u
X294 vss.t44 a_33552_852.t58 a_n132_12072.t22 vss.t43 nfet_05v0 ad=0.2132p pd=1.34u as=0.2132p ps=1.34u w=0.82u l=0.6u
X295 vss.t311 a_33552_3988.t58 a_n132_21672.t21 vss.t127 nfet_05v0 ad=0.2132p pd=1.34u as=0.2132p ps=1.34u w=0.82u l=0.6u
X296 a_n132_15272# a_n132_12872# vss.t0 ppolyf_u r_width=2u r_length=0.15m
X297 vss.t292 a_33552_2420.t44 a_n132_16872.t36 vss.t109 nfet_05v0 ad=0.2132p pd=1.34u as=0.2132p ps=1.34u w=0.82u l=0.6u
X298 a_n132_26472.t0 a_33552_5556.t39 vdd.t353 vdd.t114 pfet_05v0 ad=0.3782p pd=1.84u as=0.3782p ps=1.84u w=1.22u l=0.5u
X299 vdd.t79 a_33552_852.t20 a_n132_12072.t20 vdd.t78 pfet_05v0 ad=0.5368p pd=3.32u as=0.3782p ps=1.84u w=1.22u l=0.5u
X300 vdd.t49 a_33552_3608.t56 a_n132_19272.t4 vdd.t48 pfet_05v0 ad=0.3782p pd=1.84u as=0.3782p ps=1.84u w=1.22u l=0.5u
X301 vdd.t51 a_33552_472.t58 a_n132_9672.t2 vdd.t50 pfet_05v0 ad=0.3782p pd=1.84u as=0.3782p ps=1.84u w=1.22u l=0.5u
X302 a_33552_3988.t12 dac_code[5].t17 vss.t297 vss.t179 nfet_05v0 ad=0.2132p pd=1.34u as=0.2132p ps=1.34u w=0.82u l=0.6u
X303 a_33552_852.t12 dac_code[1].t17 vss.t339 vss.t247 nfet_05v0 ad=0.2132p pd=1.34u as=0.2132p ps=1.34u w=0.82u l=0.6u
X304 vdd.t15 a_33552_2040.t42 a_n132_14472.t18 vdd.t14 pfet_05v0 ad=0.3782p pd=1.84u as=0.3782p ps=1.84u w=1.22u l=0.5u
X305 a_n132_19272.t37 a_33552_3608.t23 vss.t108 vss.t107 nfet_05v0 ad=0.2132p pd=1.34u as=0.2132p ps=1.34u w=0.82u l=0.6u
X306 a_33552_852.t4 dac_code[1].t5 vdd.t317 vdd.t316 pfet_05v0 ad=0.3782p pd=1.84u as=0.3782p ps=1.84u w=1.22u l=0.5u
X307 a_n132_14472.t9 a_33552_2040.t51 vdd.t164 vdd.t20 pfet_05v0 ad=0.3782p pd=1.84u as=0.3782p ps=1.84u w=1.22u l=0.5u
X308 a_n132_26472.t32 a_33552_5556.t47 vss.t284 vss.t283 nfet_05v0 ad=0.2132p pd=1.34u as=0.2132p ps=1.34u w=0.82u l=0.6u
X309 a_n132_9672.t19 a_33552_472.t41 vdd.t157 vdd.t74 pfet_05v0 ad=0.3782p pd=1.84u as=0.3782p ps=1.84u w=1.22u l=0.5u
X310 vdd.t247 a_33552_5556.t36 a_n132_26472.t3 vdd.t162 pfet_05v0 ad=0.3782p pd=1.84u as=0.3782p ps=1.84u w=1.22u l=0.5u
X311 vdd.t73 a_33552_852.t28 a_n132_12072.t12 vdd.t72 pfet_05v0 ad=0.3782p pd=1.84u as=0.3782p ps=1.84u w=1.22u l=0.5u
X312 vss.t17 a_33552_3608.t32 a_n132_19272.t28 vss.t16 nfet_05v0 ad=0.2132p pd=1.34u as=0.2132p ps=1.34u w=0.82u l=0.6u
X313 a_n132_19272.t7 a_33552_3608.t53 vdd.t186 vdd.t185 pfet_05v0 ad=0.3782p pd=1.84u as=0.3782p ps=1.84u w=1.22u l=0.5u
X314 vdd.t331 dac_code[0].t16 a_33552_472.t3 vdd.t314 pfet_05v0 ad=0.3782p pd=1.84u as=0.3782p ps=1.84u w=1.22u l=0.5u
X315 vss.t190 a_33552_472.t24 a_n132_9672.t36 vss.t189 nfet_05v0 ad=0.2132p pd=1.34u as=0.2132p ps=1.34u w=0.82u l=0.6u
X316 vdd.t41 a_33552_2420.t30 a_n132_16872.t10 vdd.t40 pfet_05v0 ad=0.3782p pd=1.84u as=0.3782p ps=1.84u w=1.22u l=0.5u
X317 vdd.t3 a_33552_2040.t48 a_n132_14472.t12 vdd.t2 pfet_05v0 ad=0.3782p pd=1.84u as=0.3782p ps=1.84u w=1.22u l=0.5u
X318 vss.t166 a_33552_5556.t44 a_n132_26472.t35 vss.t165 nfet_05v0 ad=0.2132p pd=1.34u as=0.2132p ps=1.34u w=0.82u l=0.6u
X319 vdd.t305 dac_code[4].t12 a_33552_3608.t7 vdd.t288 pfet_05v0 ad=0.3782p pd=1.84u as=0.3782p ps=1.84u w=1.22u l=0.5u
X320 a_n132_26472.t6 a_33552_5556.t33 vdd.t244 vdd.t58 pfet_05v0 ad=0.3782p pd=1.84u as=0.3782p ps=1.84u w=1.22u l=0.5u
X321 a_n132_14472.t3 a_33552_2040.t57 vdd.t143 vdd.t142 pfet_05v0 ad=0.3782p pd=1.84u as=0.3782p ps=1.84u w=1.22u l=0.5u
X322 a_33552_852.t2 dac_code[1].t7 vdd.t313 vdd.t312 pfet_05v0 ad=0.3782p pd=1.84u as=0.3782p ps=1.84u w=1.22u l=0.5u
X323 a_n132_12072.t15 a_33552_852.t25 vdd.t127 vdd.t126 pfet_05v0 ad=0.3782p pd=1.84u as=0.3782p ps=1.84u w=1.22u l=0.5u
X324 vdd.t218 dac_code[3].t8 a_33552_2420.t1 vdd.t217 pfet_05v0 ad=0.3782p pd=1.84u as=0.3782p ps=1.84u w=1.22u l=0.5u
X325 vss.t70 a_33552_2040.t38 a_n132_14472.t22 vss.t43 nfet_05v0 ad=0.2132p pd=1.34u as=0.2132p ps=1.34u w=0.82u l=0.6u
X326 vdd.t169 a_33552_3608.t42 a_n132_19272.t18 vdd.t168 pfet_05v0 ad=0.3782p pd=1.84u as=0.3782p ps=1.84u w=1.22u l=0.5u
X327 vss.t128 a_33552_5176.t38 a_n132_24072.t21 vss.t127 nfet_05v0 ad=0.2132p pd=1.34u as=0.2132p ps=1.34u w=0.82u l=0.6u
X328 a_n132_9672.t0 a_29672_8872# vss.t0 ppolyf_u r_width=2u r_length=0.15m
X329 vdd.t350 dac_code[7].t2 a_33552_5556.t7 vdd.t207 pfet_05v0 ad=0.3782p pd=1.84u as=0.3782p ps=1.84u w=1.22u l=0.5u
X330 vss.t60 a_33552_472.t38 a_n132_9672.t22 vss.t59 nfet_05v0 ad=0.2132p pd=1.34u as=0.2132p ps=1.34u w=0.82u l=0.6u
X331 a_n132_19272.t9 a_33552_3608.t51 vdd.t91 vdd.t90 pfet_05v0 ad=0.3782p pd=1.84u as=0.3782p ps=1.84u w=1.22u l=0.5u
X332 vdd.t88 a_33552_472.t46 a_n132_9672.t14 vdd.t87 pfet_05v0 ad=0.3782p pd=1.84u as=0.3782p ps=1.84u w=1.22u l=0.5u
X333 a_n132_9672.t29 a_33552_472.t31 vss.t325 vss.t324 nfet_05v0 ad=0.2132p pd=1.34u as=0.2132p ps=1.34u w=0.82u l=0.6u
X334 a_33552_5176.t12 dac_code[6].t7 vss.t180 vss.t179 nfet_05v0 ad=0.2132p pd=1.34u as=0.2132p ps=1.34u w=0.82u l=0.6u
X335 a_n132_12072.t7 a_33552_852.t33 vdd.t100 vdd.t66 pfet_05v0 ad=0.3782p pd=1.84u as=0.3782p ps=1.84u w=1.22u l=0.5u
X336 a_n132_21672.t40 a_29672_20872# vss.t0 ppolyf_u r_width=2u r_length=0.15m
X337 vss.t134 a_33552_852.t50 a_n132_12072.t30 vss.t87 nfet_05v0 ad=0.2132p pd=1.34u as=0.2132p ps=1.34u w=0.82u l=0.6u
X338 a_33552_2040.t12 dac_code[2].t7 vss.t248 vss.t247 nfet_05v0 ad=0.2132p pd=1.34u as=0.2132p ps=1.34u w=0.82u l=0.6u
X339 vss.t148 a_33552_3988.t50 a_n132_21672.t29 vss.t147 nfet_05v0 ad=0.2132p pd=1.34u as=0.2132p ps=1.34u w=0.82u l=0.6u
X340 a_33552_2420.t4 dac_code[3].t5 vdd.t224 vdd.t223 pfet_05v0 ad=0.3782p pd=1.84u as=0.3782p ps=1.84u w=1.22u l=0.5u
X341 vdd.t123 a_33552_5556.t22 a_n132_26472.t17 vdd.t122 pfet_05v0 ad=0.3782p pd=1.84u as=0.3782p ps=1.84u w=1.22u l=0.5u
X342 a_n132_26472.t8 a_33552_5556.t31 vdd.t116 vdd.t24 pfet_05v0 ad=0.3782p pd=1.84u as=0.3782p ps=1.84u w=1.22u l=0.5u
X343 a_n132_19272.t33 a_33552_3608.t27 vss.t71 vss.t24 nfet_05v0 ad=0.2132p pd=1.34u as=0.2132p ps=1.34u w=0.82u l=0.6u
X344 vdd.t149 a_33552_3608.t48 a_n132_19272.t12 vdd.t148 pfet_05v0 ad=0.3782p pd=1.84u as=0.3782p ps=1.84u w=1.22u l=0.5u
X345 a_n132_16872.t15 a_33552_2420.t25 vdd.t213 vdd.t8 pfet_05v0 ad=0.3782p pd=1.84u as=0.3782p ps=1.84u w=1.22u l=0.5u
X346 vss.t296 dac_code[5].t18 a_33552_3988.t11 vss.t177 nfet_05v0 ad=0.2132p pd=1.34u as=0.2132p ps=1.34u w=0.82u l=0.6u
X347 vss.t335 dac_code[1].t18 a_33552_852.t11 vss.t245 nfet_05v0 ad=0.2132p pd=1.34u as=0.2132p ps=1.34u w=0.82u l=0.6u
X348 a_n132_14472.t17 a_33552_2040.t43 vdd.t5 vdd.t4 pfet_05v0 ad=0.3782p pd=1.84u as=0.3782p ps=1.84u w=1.22u l=0.5u
X349 a_n132_16872.t0 a_29672_16072# vss.t0 ppolyf_u r_width=2u r_length=0.15m
X350 vdd.t296 a_33552_852.t30 a_n132_12072.t10 vdd.t80 pfet_05v0 ad=0.3782p pd=1.84u as=0.3782p ps=1.84u w=1.22u l=0.5u
X351 a_n132_19272.t3 a_33552_3608.t57 vdd.t29 vdd.t28 pfet_05v0 ad=0.3782p pd=1.84u as=0.3782p ps=1.84u w=1.22u l=0.5u
X352 vdd.t119 a_33552_5556.t28 a_n132_26472.t11 vdd.t98 pfet_05v0 ad=0.3782p pd=1.84u as=0.3782p ps=1.84u w=1.22u l=0.5u
X353 vdd.t57 a_33552_2420.t34 a_n132_16872.t6 vdd.t56 pfet_05v0 ad=0.3782p pd=1.84u as=0.3782p ps=1.84u w=1.22u l=0.5u
X354 vss.t110 a_33552_3608.t24 a_n132_19272.t36 vss.t109 nfet_05v0 ad=0.2132p pd=1.34u as=0.2132p ps=1.34u w=0.82u l=0.6u
X355 vdd.t165 a_33552_2040.t52 a_n132_14472.t8 vdd.t22 pfet_05v0 ad=0.3782p pd=1.84u as=0.3782p ps=1.84u w=1.22u l=0.5u
X356 a_33552_2420.t6 dac_code[3].t3 vdd.t228 vdd.t227 pfet_05v0 ad=0.3782p pd=1.84u as=0.3782p ps=1.84u w=1.22u l=0.5u
X357 a_33552_3988.t14 dac_code[5].t15 vss.t299 vss.t183 nfet_05v0 ad=0.2132p pd=1.34u as=0.2132p ps=1.34u w=0.82u l=0.6u
X358 a_33552_852.t14 dac_code[1].t15 vss.t341 vss.t251 nfet_05v0 ad=0.2132p pd=1.34u as=0.2132p ps=1.34u w=0.82u l=0.6u
X359 a_n132_9672.t27 a_33552_472.t33 vss.t116 vss.t115 nfet_05v0 ad=0.2132p pd=1.34u as=0.2132p ps=1.34u w=0.82u l=0.6u
X360 a_n132_26472.t2 a_33552_5556.t37 vdd.t358 vdd.t174 pfet_05v0 ad=0.3782p pd=1.84u as=0.3782p ps=1.84u w=1.22u l=0.5u
X361 a_n132_10472# a_29672_11272# vss.t1 ppolyf_u r_width=2u r_length=0.14836m
X362 a_n132_9672.t1 a_33552_472.t59 vdd.t53 vdd.t52 pfet_05v0 ad=0.3782p pd=1.84u as=0.3782p ps=1.84u w=1.22u l=0.5u
X363 a_n132_12072.t35 a_33552_852.t45 vss.t187 vss.t103 nfet_05v0 ad=0.2132p pd=1.34u as=0.2132p ps=1.34u w=0.82u l=0.6u
X364 a_n132_21672.t34 a_33552_3988.t45 vss.t29 vss.t28 nfet_05v0 ad=0.2132p pd=1.34u as=0.2132p ps=1.34u w=0.82u l=0.6u
X365 vdd.t234 dac_code[3].t0 a_33552_2420.t9 vdd.t233 pfet_05v0 ad=0.3782p pd=1.84u as=0.3782p ps=1.84u w=1.22u l=0.5u
X366 vss.t88 a_33552_2040.t30 a_n132_14472.t30 vss.t87 nfet_05v0 ad=0.2132p pd=1.34u as=0.2132p ps=1.34u w=0.82u l=0.6u
X367 vss.t216 a_33552_5176.t30 a_n132_24072.t29 vss.t147 nfet_05v0 ad=0.2132p pd=1.34u as=0.2132p ps=1.34u w=0.82u l=0.6u
X368 a_n132_19272.t17 a_33552_3608.t43 vdd.t153 vdd.t152 pfet_05v0 ad=0.3782p pd=1.84u as=0.3782p ps=1.84u w=1.22u l=0.5u
X369 vss.t218 a_33552_852.t54 a_n132_12072.t26 vss.t75 nfet_05v0 ad=0.2132p pd=1.34u as=0.2132p ps=1.34u w=0.82u l=0.6u
X370 vss.t141 a_33552_3988.t54 a_n132_21672.t25 vss.t140 nfet_05v0 ad=0.2132p pd=1.34u as=0.2132p ps=1.34u w=0.82u l=0.6u
X371 a_33552_2420.t0 dac_code[3].t9 vdd.t216 vdd.t215 pfet_05v0 ad=0.3782p pd=1.84u as=0.5368p ps=3.32u w=1.22u l=0.5u
X372 vss.t38 a_33552_472.t34 a_n132_9672.t26 vss.t37 nfet_05v0 ad=0.2132p pd=1.34u as=0.2132p ps=1.34u w=0.82u l=0.6u
X373 vdd.t297 a_33552_2420.t20 a_n132_16872.t20 vdd.t32 pfet_05v0 ad=0.5368p pd=3.32u as=0.3782p ps=1.84u w=1.22u l=0.5u
X374 vss.t363 dac_code[0].t0 a_33552_472.t19 vss.t362 nfet_05v0 ad=0.2132p pd=1.34u as=0.2132p ps=1.34u w=0.82u l=0.6u
X375 a_n132_9672.t33 a_33552_472.t27 vss.t290 vss.t289 nfet_05v0 ad=0.2132p pd=1.34u as=0.2132p ps=1.34u w=0.82u l=0.6u
X376 a_33552_852.t16 dac_code[1].t13 vss.t338 vss.t255 nfet_05v0 ad=0.2132p pd=1.34u as=0.2132p ps=1.34u w=0.82u l=0.6u
X377 a_33552_3988.t16 dac_code[5].t13 vss.t301 vss.t173 nfet_05v0 ad=0.2132p pd=1.34u as=0.2132p ps=1.34u w=0.82u l=0.6u
X378 vss.t178 dac_code[6].t8 a_33552_5176.t11 vss.t177 nfet_05v0 ad=0.2132p pd=1.34u as=0.2132p ps=1.34u w=0.82u l=0.6u
X379 a_33552_852.t6 dac_code[1].t3 vdd.t321 vdd.t320 pfet_05v0 ad=0.3782p pd=1.84u as=0.3782p ps=1.84u w=1.22u l=0.5u
X380 vdd.t93 a_33552_3608.t52 a_n132_19272.t8 vdd.t92 pfet_05v0 ad=0.3782p pd=1.84u as=0.3782p ps=1.84u w=1.22u l=0.5u
X381 vss.t246 dac_code[2].t8 a_33552_2040.t11 vss.t245 nfet_05v0 ad=0.2132p pd=1.34u as=0.2132p ps=1.34u w=0.82u l=0.6u
X382 a_n132_26472.t16 a_33552_5556.t23 vdd.t249 vdd.t248 pfet_05v0 ad=0.3782p pd=1.84u as=0.3782p ps=1.84u w=1.22u l=0.5u
X383 a_n132_16872.t11 a_33552_2420.t29 vdd.t39 vdd.t38 pfet_05v0 ad=0.3782p pd=1.84u as=0.3782p ps=1.84u w=1.22u l=0.5u
X384 a_n132_14472.t13 a_33552_2040.t47 vdd.t1 vdd.t0 pfet_05v0 ad=0.3782p pd=1.84u as=0.3782p ps=1.84u w=1.22u l=0.5u
X385 vdd.t222 dac_code[3].t6 a_33552_2420.t3 vdd.t221 pfet_05v0 ad=0.3782p pd=1.84u as=0.3782p ps=1.84u w=1.22u l=0.5u
X386 vdd.t333 dac_code[0].t14 a_33552_472.t5 vdd.t318 pfet_05v0 ad=0.3782p pd=1.84u as=0.3782p ps=1.84u w=1.22u l=0.5u
X387 vss.t304 dac_code[5].t10 a_33552_3988.t19 vss.t185 nfet_05v0 ad=0.2132p pd=1.34u as=0.2132p ps=1.34u w=0.82u l=0.6u
X388 vss.t343 dac_code[1].t10 a_33552_852.t19 vss.t261 nfet_05v0 ad=0.2132p pd=1.34u as=0.2132p ps=1.34u w=0.82u l=0.6u
X389 vdd.t117 a_33552_5556.t32 a_n132_26472.t7 vdd.t26 pfet_05v0 ad=0.3782p pd=1.84u as=0.3782p ps=1.84u w=1.22u l=0.5u
X390 a_33552_5176.t14 dac_code[6].t5 vss.t184 vss.t183 nfet_05v0 ad=0.2132p pd=1.34u as=0.2132p ps=1.34u w=0.82u l=0.6u
X391 a_33552_2040.t14 dac_code[2].t5 vss.t252 vss.t251 nfet_05v0 ad=0.2132p pd=1.34u as=0.2132p ps=1.34u w=0.82u l=0.6u
X392 a_n132_9672.t13 a_33552_472.t47 vdd.t89 vdd.t70 pfet_05v0 ad=0.3782p pd=1.84u as=0.3782p ps=1.84u w=1.22u l=0.5u
X393 vdd.t214 a_33552_2420.t26 a_n132_16872.t14 vdd.t10 pfet_05v0 ad=0.3782p pd=1.84u as=0.3782p ps=1.84u w=1.22u l=0.5u
X394 a_33552_3988.t10 dac_code[5].t19 vss.t295 vss.t175 nfet_05v0 ad=0.2132p pd=1.34u as=0.3608p ps=2.52u w=0.82u l=0.6u
X395 a_33552_852.t10 dac_code[1].t19 vss.t334 vss.t243 nfet_05v0 ad=0.2132p pd=1.34u as=0.3608p ps=2.52u w=0.82u l=0.6u
X396 vdd.t7 a_33552_2040.t44 a_n132_14472.t16 vdd.t6 pfet_05v0 ad=0.3782p pd=1.84u as=0.3782p ps=1.84u w=1.22u l=0.5u
X397 vss.t368 a_33552_3988.t40 a_n132_21672.t39 vss.t263 nfet_05v0 ad=0.3608p pd=2.52u as=0.2132p ps=1.34u w=0.82u l=0.6u
X398 vss.t307 a_33552_852.t40 a_n132_12072.t40 vss.t101 nfet_05v0 ad=0.3608p pd=2.52u as=0.2132p ps=1.34u w=0.82u l=0.6u
X399 a_n132_16872.t5 a_33552_2420.t35 vdd.t158 vdd.t134 pfet_05v0 ad=0.3782p pd=1.84u as=0.3782p ps=1.84u w=1.22u l=0.5u
X400 a_n132_14472.t35 a_33552_2040.t25 vss.t104 vss.t103 nfet_05v0 ad=0.2132p pd=1.34u as=0.2132p ps=1.34u w=0.82u l=0.6u
X401 a_n132_24072.t34 a_33552_5176.t25 vss.t305 vss.t28 nfet_05v0 ad=0.2132p pd=1.34u as=0.2132p ps=1.34u w=0.82u l=0.6u
X402 a_n132_21672.t30 a_33552_3988.t49 vss.t146 vss.t145 nfet_05v0 ad=0.2132p pd=1.34u as=0.2132p ps=1.34u w=0.82u l=0.6u
X403 vdd.t311 dac_code[1].t8 a_33552_852.t1 vdd.t310 pfet_05v0 ad=0.3782p pd=1.84u as=0.3782p ps=1.84u w=1.22u l=0.5u
X404 a_n132_12072.t31 a_33552_852.t49 vss.t133 vss.t85 nfet_05v0 ad=0.2132p pd=1.34u as=0.2132p ps=1.34u w=0.82u l=0.6u
X405 vdd.t226 dac_code[3].t4 a_33552_2420.t5 vdd.t225 pfet_05v0 ad=0.3782p pd=1.84u as=0.3782p ps=1.84u w=1.22u l=0.5u
X406 vss.t340 dac_code[1].t16 a_33552_852.t13 vss.t249 nfet_05v0 ad=0.2132p pd=1.34u as=0.2132p ps=1.34u w=0.82u l=0.6u
X407 vss.t298 dac_code[5].t16 a_33552_3988.t13 vss.t181 nfet_05v0 ad=0.2132p pd=1.34u as=0.2132p ps=1.34u w=0.82u l=0.6u
X408 vss.t76 a_33552_2040.t34 a_n132_14472.t26 vss.t75 nfet_05v0 ad=0.2132p pd=1.34u as=0.2132p ps=1.34u w=0.82u l=0.6u
X409 vdd.t269 a_33552_3988.t38 a_n132_21672.t1 vdd.t30 pfet_05v0 ad=0.3782p pd=1.84u as=0.3782p ps=1.84u w=1.22u l=0.5u
X410 vss.t276 a_33552_5176.t34 a_n132_24072.t25 vss.t140 nfet_05v0 ad=0.2132p pd=1.34u as=0.2132p ps=1.34u w=0.82u l=0.6u
X411 a_n132_22472# a_29672_23272# vss.t1 ppolyf_u r_width=2u r_length=0.14836m
X412 a_n132_12072.t9 a_33552_852.t31 vdd.t264 vdd.t82 pfet_05v0 ad=0.3782p pd=1.84u as=0.3782p ps=1.84u w=1.22u l=0.5u
X413 a_33552_2040.t16 dac_code[2].t3 vss.t256 vss.t255 nfet_05v0 ad=0.2132p pd=1.34u as=0.2132p ps=1.34u w=0.82u l=0.6u
X414 a_n132_19272.t13 a_33552_3608.t47 vdd.t147 vdd.t146 pfet_05v0 ad=0.3782p pd=1.84u as=0.3782p ps=1.84u w=1.22u l=0.5u
X415 a_33552_5176.t16 dac_code[6].t3 vss.t174 vss.t173 nfet_05v0 ad=0.2132p pd=1.34u as=0.2132p ps=1.34u w=0.82u l=0.6u
X416 a_n132_12872# a_n132_10472# vss.t0 ppolyf_u r_width=2u r_length=0.15m
X417 a_33552_472.t0 dac_code[0].t19 vdd.t328 vdd.t308 pfet_05v0 ad=0.3782p pd=1.84u as=0.5368p ps=3.32u w=1.22u l=0.5u
X418 vss.t188 a_33552_852.t46 a_n132_12072.t34 vss.t105 nfet_05v0 ad=0.2132p pd=1.34u as=0.2132p ps=1.34u w=0.82u l=0.6u
X419 a_33552_3988.t2 dac_code[5].t7 vdd.t279 vdd.t278 pfet_05v0 ad=0.3782p pd=1.84u as=0.3782p ps=1.84u w=1.22u l=0.5u
X420 vss.t31 a_33552_3988.t46 a_n132_21672.t33 vss.t30 nfet_05v0 ad=0.2132p pd=1.34u as=0.2132p ps=1.34u w=0.82u l=0.6u
X421 a_33552_2420.t8 dac_code[3].t1 vdd.t232 vdd.t231 pfet_05v0 ad=0.3782p pd=1.84u as=0.3782p ps=1.84u w=1.22u l=0.5u
X422 vdd.t177 a_33552_5176.t58 a_n132_24072.t1 vdd.t176 pfet_05v0 ad=0.3782p pd=1.84u as=0.3782p ps=1.84u w=1.22u l=0.5u
X423 vdd.t65 a_33552_472.t52 a_n132_9672.t8 vdd.t64 pfet_05v0 ad=0.3782p pd=1.84u as=0.3782p ps=1.84u w=1.22u l=0.5u
X424 a_n132_12072.t25 a_33552_852.t55 vss.t159 vss.t53 nfet_05v0 ad=0.2132p pd=1.34u as=0.2132p ps=1.34u w=0.82u l=0.6u
X425 a_n132_21672.t24 a_33552_3988.t55 vss.t331 vss.t330 nfet_05v0 ad=0.2132p pd=1.34u as=0.2132p ps=1.34u w=0.82u l=0.6u
X426 a_n132_17672# a_29672_18472# vss.t1 ppolyf_u r_width=2u r_length=0.14836m
X427 a_n132_26472.t12 a_33552_5556.t27 vdd.t118 vdd.t96 pfet_05v0 ad=0.3782p pd=1.84u as=0.3782p ps=1.84u w=1.22u l=0.5u
X428 vss.t19 a_33552_472.t36 a_n132_9672.t24 vss.t18 nfet_05v0 ad=0.2132p pd=1.34u as=0.2132p ps=1.34u w=0.82u l=0.6u
X429 vdd.t155 a_33552_3608.t44 a_n132_19272.t16 vdd.t154 pfet_05v0 ad=0.3782p pd=1.84u as=0.3782p ps=1.84u w=1.22u l=0.5u
X430 vss.t186 dac_code[6].t0 a_33552_5176.t19 vss.t185 nfet_05v0 ad=0.2132p pd=1.34u as=0.2132p ps=1.34u w=0.82u l=0.6u
X431 vss.t262 dac_code[2].t0 a_33552_2040.t19 vss.t261 nfet_05v0 ad=0.2132p pd=1.34u as=0.2132p ps=1.34u w=0.82u l=0.6u
X432 a_n132_16872.t19 a_33552_2420.t21 vdd.t266 vdd.t12 pfet_05v0 ad=0.3782p pd=1.84u as=0.3782p ps=1.84u w=1.22u l=0.5u
X433 vss.t337 dac_code[1].t14 a_33552_852.t15 vss.t253 nfet_05v0 ad=0.2132p pd=1.34u as=0.2132p ps=1.34u w=0.82u l=0.6u
X434 vss.t300 dac_code[5].t14 a_33552_3988.t15 vss.t171 nfet_05v0 ad=0.2132p pd=1.34u as=0.2132p ps=1.34u w=0.82u l=0.6u
X435 a_33552_5176.t2 dac_code[6].t17 vdd.t198 vdd.t197 pfet_05v0 ad=0.3782p pd=1.84u as=0.3782p ps=1.84u w=1.22u l=0.5u
X436 a_33552_5176.t10 dac_code[6].t9 vss.t176 vss.t175 nfet_05v0 ad=0.2132p pd=1.34u as=0.3608p ps=2.52u w=0.82u l=0.6u
X437 a_33552_2040.t10 dac_code[2].t9 vss.t244 vss.t243 nfet_05v0 ad=0.2132p pd=1.34u as=0.3608p ps=2.52u w=0.82u l=0.6u
X438 vss.t264 a_33552_5176.t20 a_n132_24072.t39 vss.t263 nfet_05v0 ad=0.3608p pd=2.52u as=0.2132p ps=1.34u w=0.82u l=0.6u
X439 vss.t102 a_33552_2040.t20 a_n132_14472.t40 vss.t101 nfet_05v0 ad=0.3608p pd=2.52u as=0.2132p ps=1.34u w=0.82u l=0.6u
X440 vdd.t251 a_33552_5556.t24 a_n132_26472.t15 vdd.t250 pfet_05v0 ad=0.3782p pd=1.84u as=0.3782p ps=1.84u w=1.22u l=0.5u
X441 a_n132_9672.t11 a_33552_472.t49 vdd.t86 vdd.t85 pfet_05v0 ad=0.3782p pd=1.84u as=0.3782p ps=1.84u w=1.22u l=0.5u
X442 vdd.t125 a_33552_852.t36 a_n132_12072.t4 vdd.t16 pfet_05v0 ad=0.3782p pd=1.84u as=0.3782p ps=1.84u w=1.22u l=0.5u
X443 a_n132_16872.t1 a_33552_2420.t39 vdd.t111 vdd.t110 pfet_05v0 ad=0.3782p pd=1.84u as=0.3782p ps=1.84u w=1.22u l=0.5u
X444 a_33552_3988.t18 dac_code[5].t11 vss.t303 vss.t169 nfet_05v0 ad=0.2132p pd=1.34u as=0.2132p ps=1.34u w=0.82u l=0.6u
X445 a_33552_852.t18 dac_code[1].t11 vss.t336 vss.t259 nfet_05v0 ad=0.2132p pd=1.34u as=0.2132p ps=1.34u w=0.82u l=0.6u
X446 a_n132_24072.t30 a_33552_5176.t29 vss.t215 vss.t145 nfet_05v0 ad=0.2132p pd=1.34u as=0.2132p ps=1.34u w=0.82u l=0.6u
X447 a_n132_14472.t31 a_33552_2040.t29 vss.t86 vss.t85 nfet_05v0 ad=0.2132p pd=1.34u as=0.2132p ps=1.34u w=0.82u l=0.6u
X448 a_33552_472.t16 dac_code[0].t3 vss.t359 vss.t358 nfet_05v0 ad=0.2132p pd=1.34u as=0.2132p ps=1.34u w=0.82u l=0.6u
X449 vss.t182 dac_code[6].t6 a_33552_5176.t13 vss.t181 nfet_05v0 ad=0.2132p pd=1.34u as=0.2132p ps=1.34u w=0.82u l=0.6u
X450 vss.t250 dac_code[2].t6 a_33552_2040.t13 vss.t249 nfet_05v0 ad=0.2132p pd=1.34u as=0.2132p ps=1.34u w=0.82u l=0.6u
X451 a_n132_9672.t3 a_33552_472.t57 vdd.t19 vdd.t18 pfet_05v0 ad=0.3782p pd=1.84u as=0.3782p ps=1.84u w=1.22u l=0.5u
X452 a_n132_21672.t38 a_33552_3988.t41 vss.t122 vss.t121 nfet_05v0 ad=0.2132p pd=1.34u as=0.2132p ps=1.34u w=0.82u l=0.6u
X453 a_n132_12072.t39 a_33552_852.t41 vss.t265 vss.t97 nfet_05v0 ad=0.2132p pd=1.34u as=0.2132p ps=1.34u w=0.82u l=0.6u
X454 vdd.t159 a_33552_2420.t36 a_n132_16872.t4 vdd.t136 pfet_05v0 ad=0.3782p pd=1.84u as=0.3782p ps=1.84u w=1.22u l=0.5u
X455 vss.t106 a_33552_2040.t26 a_n132_14472.t34 vss.t105 nfet_05v0 ad=0.2132p pd=1.34u as=0.2132p ps=1.34u w=0.82u l=0.6u
X456 vdd.t340 a_33552_3988.t30 a_n132_21672.t9 vdd.t132 pfet_05v0 ad=0.3782p pd=1.84u as=0.3782p ps=1.84u w=1.22u l=0.5u
X457 vss.t306 a_33552_5176.t26 a_n132_24072.t33 vss.t30 nfet_05v0 ad=0.2132p pd=1.34u as=0.2132p ps=1.34u w=0.82u l=0.6u
X458 vss.t327 a_33552_472.t20 a_n132_9672.t40 vss.t326 nfet_05v0 ad=0.3608p pd=2.52u as=0.2132p ps=1.34u w=0.82u l=0.6u
X459 a_n132_14472.t25 a_33552_2040.t35 vss.t54 vss.t53 nfet_05v0 ad=0.2132p pd=1.34u as=0.2132p ps=1.34u w=0.82u l=0.6u
X460 a_n132_24072.t24 a_33552_5176.t35 vss.t369 vss.t330 nfet_05v0 ad=0.2132p pd=1.34u as=0.2132p ps=1.34u w=0.82u l=0.6u
X461 vss.t309 a_33552_2420.t58 a_n132_16872.t22 vss.t4 nfet_05v0 ad=0.2132p pd=1.34u as=0.2132p ps=1.34u w=0.82u l=0.6u
X462 vdd.t35 a_33552_472.t54 a_n132_9672.t6 vdd.t34 pfet_05v0 ad=0.3782p pd=1.84u as=0.3782p ps=1.84u w=1.22u l=0.5u
X463 a_n132_12072.t21 a_33552_852.t59 vss.t23 vss.t22 nfet_05v0 ad=0.2132p pd=1.34u as=0.2132p ps=1.34u w=0.82u l=0.6u
X464 a_n132_21672.t20 a_33552_3988.t59 vss.t268 vss.t213 nfet_05v0 ad=0.2132p pd=1.34u as=0.2132p ps=1.34u w=0.82u l=0.6u
X465 a_n132_16872.t7 a_33552_2420.t33 vdd.t55 vdd.t54 pfet_05v0 ad=0.3782p pd=1.84u as=0.3782p ps=1.84u w=1.22u l=0.5u
X466 vss.t172 dac_code[6].t4 a_33552_5176.t15 vss.t171 nfet_05v0 ad=0.2132p pd=1.34u as=0.2132p ps=1.34u w=0.82u l=0.6u
X467 a_33552_852.t8 dac_code[1].t1 vdd.t327 vdd.t326 pfet_05v0 ad=0.3782p pd=1.84u as=0.3782p ps=1.84u w=1.22u l=0.5u
X468 vout.t0 a_n132_22472# vss.t0 ppolyf_u r_width=2u r_length=0.15m
X469 vdd.t45 a_33552_5176.t50 a_n132_24072.t9 vdd.t44 pfet_05v0 ad=0.3782p pd=1.84u as=0.3782p ps=1.84u w=1.22u l=0.5u
X470 vss.t254 dac_code[2].t4 a_33552_2040.t15 vss.t253 nfet_05v0 ad=0.2132p pd=1.34u as=0.2132p ps=1.34u w=0.82u l=0.6u
X471 vdd.t277 dac_code[5].t8 a_33552_3988.t1 vdd.t276 pfet_05v0 ad=0.3782p pd=1.84u as=0.3782p ps=1.84u w=1.22u l=0.5u
X472 a_33552_2420.t12 dac_code[3].t17 vss.t196 vss.t195 nfet_05v0 ad=0.2132p pd=1.34u as=0.2132p ps=1.34u w=0.82u l=0.6u
X473 vdd.t230 dac_code[3].t2 a_33552_2420.t7 vdd.t229 pfet_05v0 ad=0.3782p pd=1.84u as=0.3782p ps=1.84u w=1.22u l=0.5u
X474 vdd.t105 a_33552_852.t24 a_n132_12072.t16 vdd.t104 pfet_05v0 ad=0.3782p pd=1.84u as=0.3782p ps=1.84u w=1.22u l=0.5u
X475 a_33552_472.t14 dac_code[0].t5 vss.t353 vss.t352 nfet_05v0 ad=0.2132p pd=1.34u as=0.2132p ps=1.34u w=0.82u l=0.6u
X476 vss.t114 a_33552_472.t32 a_n132_9672.t28 vss.t113 nfet_05v0 ad=0.2132p pd=1.34u as=0.2132p ps=1.34u w=0.82u l=0.6u
X477 a_n132_7272# vss.t142 vss.t0 ppolyf_u r_width=2u r_length=0.15m
X478 vdd.t335 dac_code[0].t12 a_33552_472.t7 vdd.t322 pfet_05v0 ad=0.3782p pd=1.84u as=0.3782p ps=1.84u w=1.22u l=0.5u
X479 vss.t160 a_33552_852.t56 a_n132_12072.t24 vss.t55 nfet_05v0 ad=0.2132p pd=1.34u as=0.2132p ps=1.34u w=0.82u l=0.6u
X480 vss.t333 a_33552_3988.t56 a_n132_21672.t23 vss.t332 nfet_05v0 ad=0.2132p pd=1.34u as=0.2132p ps=1.34u w=0.82u l=0.6u
X481 a_33552_5176.t18 dac_code[6].t1 vss.t170 vss.t169 nfet_05v0 ad=0.2132p pd=1.34u as=0.2132p ps=1.34u w=0.82u l=0.6u
X482 a_33552_2040.t18 dac_code[2].t1 vss.t260 vss.t259 nfet_05v0 ad=0.2132p pd=1.34u as=0.2132p ps=1.34u w=0.82u l=0.6u
X483 a_33552_3988.t4 dac_code[5].t5 vdd.t283 vdd.t282 pfet_05v0 ad=0.3782p pd=1.84u as=0.3782p ps=1.84u w=1.22u l=0.5u
X484 vdd.t196 dac_code[6].t18 a_33552_5176.t1 vdd.t195 pfet_05v0 ad=0.3782p pd=1.84u as=0.3782p ps=1.84u w=1.22u l=0.5u
X485 vdd.t69 a_33552_852.t38 a_n132_12072.t2 vdd.t50 pfet_05v0 ad=0.3782p pd=1.84u as=0.3782p ps=1.84u w=1.22u l=0.5u
X486 vdd.t267 a_33552_2420.t22 a_n132_16872.t18 vdd.t14 pfet_05v0 ad=0.3782p pd=1.84u as=0.3782p ps=1.84u w=1.22u l=0.5u
X487 vss.t234 a_33552_5556.t58 a_n132_26472.t21 vss.t233 nfet_05v0 ad=0.2132p pd=1.34u as=0.2132p ps=1.34u w=0.82u l=0.6u
X488 a_n132_16872.t9 a_33552_2420.t31 vdd.t21 vdd.t20 pfet_05v0 ad=0.3782p pd=1.84u as=0.3782p ps=1.84u w=1.22u l=0.5u
X489 a_n132_21672.t26 a_33552_3988.t53 vss.t139 vss.t138 nfet_05v0 ad=0.2132p pd=1.34u as=0.2132p ps=1.34u w=0.82u l=0.6u
X490 a_n132_12072.t27 a_33552_852.t53 vss.t217 vss.t73 nfet_05v0 ad=0.2132p pd=1.34u as=0.2132p ps=1.34u w=0.82u l=0.6u
X491 a_n132_24072.t38 a_33552_5176.t21 vss.t269 vss.t121 nfet_05v0 ad=0.2132p pd=1.34u as=0.2132p ps=1.34u w=0.82u l=0.6u
X492 a_n132_12072.t19 a_33552_852.t21 vdd.t75 vdd.t74 pfet_05v0 ad=0.3782p pd=1.84u as=0.3782p ps=1.84u w=1.22u l=0.5u
X493 a_n132_14472.t39 a_33552_2040.t21 vss.t98 vss.t97 nfet_05v0 ad=0.2132p pd=1.34u as=0.2132p ps=1.34u w=0.82u l=0.6u
X494 a_n132_21672.t14 a_33552_3988.t25 vdd.t189 vdd.t138 pfet_05v0 ad=0.3782p pd=1.84u as=0.3782p ps=1.84u w=1.22u l=0.5u
X495 a_33552_5176.t4 dac_code[6].t15 vdd.t202 vdd.t201 pfet_05v0 ad=0.3782p pd=1.84u as=0.3782p ps=1.84u w=1.22u l=0.5u
X496 a_33552_5556.t12 dac_code[7].t17 vss.t376 vss.t375 nfet_05v0 ad=0.2132p pd=1.34u as=0.2132p ps=1.34u w=0.82u l=0.6u
X497 vdd.t315 dac_code[1].t6 a_33552_852.t3 vdd.t314 pfet_05v0 ad=0.3782p pd=1.84u as=0.3782p ps=1.84u w=1.22u l=0.5u
X498 a_n132_9672.t21 a_33552_472.t39 vss.t62 vss.t61 nfet_05v0 ad=0.2132p pd=1.34u as=0.2132p ps=1.34u w=0.82u l=0.6u
X499 vss.t302 dac_code[5].t12 a_33552_3988.t17 vss.t167 nfet_05v0 ad=0.2132p pd=1.34u as=0.2132p ps=1.34u w=0.82u l=0.6u
X500 a_n132_14472.t0 a_29672_13672# vss.t0 ppolyf_u r_width=2u r_length=0.15m
X501 vss.t342 dac_code[1].t12 a_33552_852.t17 vss.t257 nfet_05v0 ad=0.2132p pd=1.34u as=0.2132p ps=1.34u w=0.82u l=0.6u
X502 vdd.t170 a_33552_472.t42 a_n132_9672.t18 vdd.t76 pfet_05v0 ad=0.3782p pd=1.84u as=0.3782p ps=1.84u w=1.22u l=0.5u
X503 vdd.t236 a_33552_3988.t34 a_n132_21672.t5 vdd.t187 pfet_05v0 ad=0.3782p pd=1.84u as=0.3782p ps=1.84u w=1.22u l=0.5u
X504 vdd.t113 a_33552_2420.t28 a_n132_16872.t12 vdd.t2 pfet_05v0 ad=0.3782p pd=1.84u as=0.3782p ps=1.84u w=1.22u l=0.5u
R0 dac_code[0] dac_code[0].n18 22.0504
R1 dac_code[0].n18 dac_code[0].n16 1.72411
R2 dac_code[0].n16 dac_code[0].n17 1.01439
R3 dac_code[0].n17 dac_code[0].t5 11.2547
R4 dac_code[0].n16 dac_code[0].t15 13.6515
R5 dac_code[0].n17 dac_code[0].n14 21.6977
R6 dac_code[0].n14 dac_code[0].n15 1.01439
R7 dac_code[0].n15 dac_code[0].t4 11.2547
R8 dac_code[0].n14 dac_code[0].t14 13.6515
R9 dac_code[0].n15 dac_code[0].n12 21.6977
R10 dac_code[0].n12 dac_code[0].n13 1.01439
R11 dac_code[0].n13 dac_code[0].t3 11.2547
R12 dac_code[0].n12 dac_code[0].t13 13.6515
R13 dac_code[0].n13 dac_code[0].n10 21.6977
R14 dac_code[0].n10 dac_code[0].n11 1.01439
R15 dac_code[0].n11 dac_code[0].n9 16.6283
R16 dac_code[0].n11 dac_code[0].t2 11.2547
R17 dac_code[0].n10 dac_code[0].t12 13.6515
R18 dac_code[0].n9 dac_code[0].n7 4.2345
R19 dac_code[0].n7 dac_code[0].t1 9.91633
R20 dac_code[0].n7 dac_code[0].n8 38.79
R21 dac_code[0].n8 dac_code[0].t0 14.8682
R22 dac_code[0].n8 dac_code[0].t10 16.2065
R23 dac_code[0].n9 dac_code[0].t11 16.2795
R24 dac_code[0].n6 dac_code[0].n5 1.01439
R25 dac_code[0].n18 dac_code[0].n6 19.9741
R26 dac_code[0].n6 dac_code[0].t6 11.2547
R27 dac_code[0].n5 dac_code[0].t16 13.6515
R28 dac_code[0].n4 dac_code[0].n3 1.01439
R29 dac_code[0].n5 dac_code[0].n4 21.6977
R30 dac_code[0].n4 dac_code[0].t7 11.2547
R31 dac_code[0].n3 dac_code[0].t17 13.6515
R32 dac_code[0].n2 dac_code[0].n1 1.01439
R33 dac_code[0].n3 dac_code[0].n2 21.6977
R34 dac_code[0].n2 dac_code[0].t8 11.2547
R35 dac_code[0].n1 dac_code[0].t18 13.6515
R36 dac_code[0].n1 dac_code[0].n0 21.6977
R37 dac_code[0].n0 dac_code[0].t9 11.2547
R38 dac_code[0].n0 dac_code[0].t19 14.6654
R39 dac_code[1] dac_code[1].n10 22.0504
R40 dac_code[1].n10 dac_code[1].t5 15.8415
R41 dac_code[1].n10 dac_code[1].t15 13.4447
R42 dac_code[1].n10 dac_code[1].n3 10.5449
R43 dac_code[1].n10 dac_code[1].n9 10.5449
R44 dac_code[1].n9 dac_code[1].t4 15.8415
R45 dac_code[1].n9 dac_code[1].t14 13.4447
R46 dac_code[1].n9 dac_code[1].n8 10.5449
R47 dac_code[1].n8 dac_code[1].t3 15.8415
R48 dac_code[1].n8 dac_code[1].t13 13.4447
R49 dac_code[1].n8 dac_code[1].n7 10.5449
R50 dac_code[1].n7 dac_code[1].t2 15.8415
R51 dac_code[1].n7 dac_code[1].t12 13.4447
R52 dac_code[1].n7 dac_code[1].n6 10.5449
R53 dac_code[1].n6 dac_code[1].n4 4.2345
R54 dac_code[1].n6 dac_code[1].t1 16.2795
R55 dac_code[1].n4 dac_code[1].t11 9.91633
R56 dac_code[1].n4 dac_code[1].n5 38.79
R57 dac_code[1].n5 dac_code[1].t0 16.2065
R58 dac_code[1].n5 dac_code[1].t10 14.8682
R59 dac_code[1].n3 dac_code[1].t6 15.8415
R60 dac_code[1].n3 dac_code[1].t16 13.4447
R61 dac_code[1].n3 dac_code[1].n2 10.5449
R62 dac_code[1].n2 dac_code[1].t7 15.8415
R63 dac_code[1].n2 dac_code[1].t17 13.4447
R64 dac_code[1].n2 dac_code[1].n1 10.5449
R65 dac_code[1].n1 dac_code[1].t8 15.8415
R66 dac_code[1].n1 dac_code[1].t18 13.4447
R67 dac_code[1].n1 dac_code[1].n0 10.5449
R68 dac_code[1].n0 dac_code[1].t9 15.8415
R69 dac_code[1].n0 dac_code[1].t19 13.4447
R70 dac_code[2] dac_code[2].n18 22.0504
R71 dac_code[2].n18 dac_code[2].n16 1.72411
R72 dac_code[2].n16 dac_code[2].n17 1.01439
R73 dac_code[2].n17 dac_code[2].t5 11.2547
R74 dac_code[2].n16 dac_code[2].t15 13.6515
R75 dac_code[2].n17 dac_code[2].n14 21.6977
R76 dac_code[2].n14 dac_code[2].n15 1.01439
R77 dac_code[2].n15 dac_code[2].t4 11.2547
R78 dac_code[2].n14 dac_code[2].t14 13.6515
R79 dac_code[2].n15 dac_code[2].n12 21.6977
R80 dac_code[2].n12 dac_code[2].n13 1.01439
R81 dac_code[2].n13 dac_code[2].t3 11.2547
R82 dac_code[2].n12 dac_code[2].t13 13.6515
R83 dac_code[2].n13 dac_code[2].n10 21.6977
R84 dac_code[2].n10 dac_code[2].n11 1.01439
R85 dac_code[2].n11 dac_code[2].n9 16.6283
R86 dac_code[2].n11 dac_code[2].t2 11.2547
R87 dac_code[2].n10 dac_code[2].t12 13.6515
R88 dac_code[2].n9 dac_code[2].n7 4.2345
R89 dac_code[2].n7 dac_code[2].t1 9.91633
R90 dac_code[2].n7 dac_code[2].n8 38.79
R91 dac_code[2].n8 dac_code[2].t0 14.8682
R92 dac_code[2].n8 dac_code[2].t10 16.2065
R93 dac_code[2].n9 dac_code[2].t11 16.2795
R94 dac_code[2].n6 dac_code[2].n5 1.01439
R95 dac_code[2].n18 dac_code[2].n6 19.9741
R96 dac_code[2].n6 dac_code[2].t6 11.2547
R97 dac_code[2].n5 dac_code[2].t16 13.6515
R98 dac_code[2].n4 dac_code[2].n3 1.01439
R99 dac_code[2].n5 dac_code[2].n4 21.6977
R100 dac_code[2].n4 dac_code[2].t7 11.2547
R101 dac_code[2].n3 dac_code[2].t17 13.6515
R102 dac_code[2].n2 dac_code[2].n1 1.01439
R103 dac_code[2].n3 dac_code[2].n2 21.6977
R104 dac_code[2].n2 dac_code[2].t8 11.2547
R105 dac_code[2].n1 dac_code[2].t18 13.6515
R106 dac_code[2].n1 dac_code[2].n0 21.6977
R107 dac_code[2].n0 dac_code[2].t9 11.2547
R108 dac_code[2].n0 dac_code[2].t19 14.6654
R109 dac_code[3] dac_code[3].n10 22.0504
R110 dac_code[3].n10 dac_code[3].t5 15.8415
R111 dac_code[3].n10 dac_code[3].t15 13.4447
R112 dac_code[3].n10 dac_code[3].n3 10.5449
R113 dac_code[3].n10 dac_code[3].n9 10.5449
R114 dac_code[3].n9 dac_code[3].t4 15.8415
R115 dac_code[3].n9 dac_code[3].t14 13.4447
R116 dac_code[3].n9 dac_code[3].n8 10.5449
R117 dac_code[3].n8 dac_code[3].t3 15.8415
R118 dac_code[3].n8 dac_code[3].t13 13.4447
R119 dac_code[3].n8 dac_code[3].n7 10.5449
R120 dac_code[3].n7 dac_code[3].t2 15.8415
R121 dac_code[3].n7 dac_code[3].t12 13.4447
R122 dac_code[3].n7 dac_code[3].n6 10.5449
R123 dac_code[3].n6 dac_code[3].n4 4.2345
R124 dac_code[3].n6 dac_code[3].t1 16.2795
R125 dac_code[3].n4 dac_code[3].t11 9.91633
R126 dac_code[3].n4 dac_code[3].n5 38.79
R127 dac_code[3].n5 dac_code[3].t0 16.2065
R128 dac_code[3].n5 dac_code[3].t10 14.8682
R129 dac_code[3].n3 dac_code[3].t6 15.8415
R130 dac_code[3].n3 dac_code[3].t16 13.4447
R131 dac_code[3].n3 dac_code[3].n2 10.5449
R132 dac_code[3].n2 dac_code[3].t7 15.8415
R133 dac_code[3].n2 dac_code[3].t17 13.4447
R134 dac_code[3].n2 dac_code[3].n1 10.5449
R135 dac_code[3].n1 dac_code[3].t8 15.8415
R136 dac_code[3].n1 dac_code[3].t18 13.4447
R137 dac_code[3].n1 dac_code[3].n0 10.5449
R138 dac_code[3].n0 dac_code[3].t9 15.8415
R139 dac_code[3].n0 dac_code[3].t19 13.4447
R140 dac_code[4] dac_code[4].n18 22.0504
R141 dac_code[4].n18 dac_code[4].n16 1.72411
R142 dac_code[4].n16 dac_code[4].n17 1.01439
R143 dac_code[4].n17 dac_code[4].t5 11.2547
R144 dac_code[4].n16 dac_code[4].t15 13.6515
R145 dac_code[4].n17 dac_code[4].n14 21.6977
R146 dac_code[4].n14 dac_code[4].n15 1.01439
R147 dac_code[4].n15 dac_code[4].t4 11.2547
R148 dac_code[4].n14 dac_code[4].t14 13.6515
R149 dac_code[4].n15 dac_code[4].n12 21.6977
R150 dac_code[4].n12 dac_code[4].n13 1.01439
R151 dac_code[4].n13 dac_code[4].t3 11.2547
R152 dac_code[4].n12 dac_code[4].t13 13.6515
R153 dac_code[4].n13 dac_code[4].n10 21.6977
R154 dac_code[4].n10 dac_code[4].n11 1.01439
R155 dac_code[4].n11 dac_code[4].n9 16.6283
R156 dac_code[4].n11 dac_code[4].t2 11.2547
R157 dac_code[4].n10 dac_code[4].t12 13.6515
R158 dac_code[4].n9 dac_code[4].n7 4.2345
R159 dac_code[4].n7 dac_code[4].t1 9.91633
R160 dac_code[4].n7 dac_code[4].n8 38.79
R161 dac_code[4].n8 dac_code[4].t0 14.8682
R162 dac_code[4].n8 dac_code[4].t10 16.2065
R163 dac_code[4].n9 dac_code[4].t11 16.2795
R164 dac_code[4].n6 dac_code[4].n5 1.01439
R165 dac_code[4].n18 dac_code[4].n6 19.9741
R166 dac_code[4].n6 dac_code[4].t6 11.2547
R167 dac_code[4].n5 dac_code[4].t16 13.6515
R168 dac_code[4].n4 dac_code[4].n3 1.01439
R169 dac_code[4].n5 dac_code[4].n4 21.6977
R170 dac_code[4].n4 dac_code[4].t7 11.2547
R171 dac_code[4].n3 dac_code[4].t17 13.6515
R172 dac_code[4].n2 dac_code[4].n1 1.01439
R173 dac_code[4].n3 dac_code[4].n2 21.6977
R174 dac_code[4].n2 dac_code[4].t8 11.2547
R175 dac_code[4].n1 dac_code[4].t18 13.6515
R176 dac_code[4].n1 dac_code[4].n0 21.6977
R177 dac_code[4].n0 dac_code[4].t9 11.2547
R178 dac_code[4].n0 dac_code[4].t19 14.6654
R179 dac_code[5] dac_code[5].n10 22.0504
R180 dac_code[5].n10 dac_code[5].t5 15.8415
R181 dac_code[5].n10 dac_code[5].t15 13.4447
R182 dac_code[5].n10 dac_code[5].n3 10.5449
R183 dac_code[5].n10 dac_code[5].n9 10.5449
R184 dac_code[5].n9 dac_code[5].t4 15.8415
R185 dac_code[5].n9 dac_code[5].t14 13.4447
R186 dac_code[5].n9 dac_code[5].n8 10.5449
R187 dac_code[5].n8 dac_code[5].t3 15.8415
R188 dac_code[5].n8 dac_code[5].t13 13.4447
R189 dac_code[5].n8 dac_code[5].n7 10.5449
R190 dac_code[5].n7 dac_code[5].t2 15.8415
R191 dac_code[5].n7 dac_code[5].t12 13.4447
R192 dac_code[5].n7 dac_code[5].n6 10.5449
R193 dac_code[5].n6 dac_code[5].n4 4.2345
R194 dac_code[5].n6 dac_code[5].t1 16.2795
R195 dac_code[5].n4 dac_code[5].t11 9.91633
R196 dac_code[5].n4 dac_code[5].n5 38.79
R197 dac_code[5].n5 dac_code[5].t0 16.2065
R198 dac_code[5].n5 dac_code[5].t10 14.8682
R199 dac_code[5].n3 dac_code[5].t6 15.8415
R200 dac_code[5].n3 dac_code[5].t16 13.4447
R201 dac_code[5].n3 dac_code[5].n2 10.5449
R202 dac_code[5].n2 dac_code[5].t7 15.8415
R203 dac_code[5].n2 dac_code[5].t17 13.4447
R204 dac_code[5].n2 dac_code[5].n1 10.5449
R205 dac_code[5].n1 dac_code[5].t8 15.8415
R206 dac_code[5].n1 dac_code[5].t18 13.4447
R207 dac_code[5].n1 dac_code[5].n0 10.5449
R208 dac_code[5].n0 dac_code[5].t9 15.8415
R209 dac_code[5].n0 dac_code[5].t19 13.4447
R210 dac_code[6] dac_code[6].n18 22.0504
R211 dac_code[6].n18 dac_code[6].n16 1.72411
R212 dac_code[6].n16 dac_code[6].n17 1.01439
R213 dac_code[6].n17 dac_code[6].t5 11.2547
R214 dac_code[6].n16 dac_code[6].t15 13.6515
R215 dac_code[6].n17 dac_code[6].n14 21.6977
R216 dac_code[6].n14 dac_code[6].n15 1.01439
R217 dac_code[6].n15 dac_code[6].t4 11.2547
R218 dac_code[6].n14 dac_code[6].t14 13.6515
R219 dac_code[6].n15 dac_code[6].n12 21.6977
R220 dac_code[6].n12 dac_code[6].n13 1.01439
R221 dac_code[6].n13 dac_code[6].t3 11.2547
R222 dac_code[6].n12 dac_code[6].t13 13.6515
R223 dac_code[6].n13 dac_code[6].n10 21.6977
R224 dac_code[6].n10 dac_code[6].n11 1.01439
R225 dac_code[6].n11 dac_code[6].n9 16.6283
R226 dac_code[6].n11 dac_code[6].t2 11.2547
R227 dac_code[6].n10 dac_code[6].t12 13.6515
R228 dac_code[6].n9 dac_code[6].n7 4.2345
R229 dac_code[6].n7 dac_code[6].t1 9.91633
R230 dac_code[6].n7 dac_code[6].n8 38.79
R231 dac_code[6].n8 dac_code[6].t0 14.8682
R232 dac_code[6].n8 dac_code[6].t10 16.2065
R233 dac_code[6].n9 dac_code[6].t11 16.2795
R234 dac_code[6].n6 dac_code[6].n5 1.01439
R235 dac_code[6].n18 dac_code[6].n6 19.9741
R236 dac_code[6].n6 dac_code[6].t6 11.2547
R237 dac_code[6].n5 dac_code[6].t16 13.6515
R238 dac_code[6].n4 dac_code[6].n3 1.01439
R239 dac_code[6].n5 dac_code[6].n4 21.6977
R240 dac_code[6].n4 dac_code[6].t7 11.2547
R241 dac_code[6].n3 dac_code[6].t17 13.6515
R242 dac_code[6].n2 dac_code[6].n1 1.01439
R243 dac_code[6].n3 dac_code[6].n2 21.6977
R244 dac_code[6].n2 dac_code[6].t8 11.2547
R245 dac_code[6].n1 dac_code[6].t18 13.6515
R246 dac_code[6].n1 dac_code[6].n0 21.6977
R247 dac_code[6].n0 dac_code[6].t9 11.2547
R248 dac_code[6].n0 dac_code[6].t19 14.6654
R249 dac_code[7] dac_code[7].n10 22.0504
R250 dac_code[7].n10 dac_code[7].t5 15.8415
R251 dac_code[7].n10 dac_code[7].t15 13.4447
R252 dac_code[7].n10 dac_code[7].n3 10.5449
R253 dac_code[7].n10 dac_code[7].n9 10.5449
R254 dac_code[7].n9 dac_code[7].t4 15.8415
R255 dac_code[7].n9 dac_code[7].t14 13.4447
R256 dac_code[7].n9 dac_code[7].n8 10.5449
R257 dac_code[7].n8 dac_code[7].t3 15.8415
R258 dac_code[7].n8 dac_code[7].t13 13.4447
R259 dac_code[7].n8 dac_code[7].n7 10.5449
R260 dac_code[7].n7 dac_code[7].t2 15.8415
R261 dac_code[7].n7 dac_code[7].t12 13.4447
R262 dac_code[7].n7 dac_code[7].n6 10.5449
R263 dac_code[7].n6 dac_code[7].n4 4.2345
R264 dac_code[7].n6 dac_code[7].t1 16.2795
R265 dac_code[7].n4 dac_code[7].t11 9.91633
R266 dac_code[7].n4 dac_code[7].n5 38.79
R267 dac_code[7].n5 dac_code[7].t0 16.2065
R268 dac_code[7].n5 dac_code[7].t10 14.8682
R269 dac_code[7].n3 dac_code[7].t6 15.8415
R270 dac_code[7].n3 dac_code[7].t16 13.4447
R271 dac_code[7].n3 dac_code[7].n2 10.5449
R272 dac_code[7].n2 dac_code[7].t7 15.8415
R273 dac_code[7].n2 dac_code[7].t17 13.4447
R274 dac_code[7].n2 dac_code[7].n1 10.5449
R275 dac_code[7].n1 dac_code[7].t8 15.8415
R276 dac_code[7].n1 dac_code[7].t18 13.4447
R277 dac_code[7].n1 dac_code[7].n0 10.5449
R278 dac_code[7].n0 dac_code[7].t9 15.8415
R279 dac_code[7].n0 dac_code[7].t19 13.4447
R280 vout vout.n0 21.3102
R281 vout.n0 vout.t0 52.9921
R282 vout.n0 vout.t1 43.0921
R283 vdd.n91 vdd.n137 1.7645
R284 vdd.n45 vdd.n91 1.7645
R285 vdd vdd.n45 47.3918
R286 vdd.n181 vdd.n182 0.3215
R287 vdd.n178 vdd.n181 0.3365
R288 vdd.n175 vdd.n178 0.3365
R289 vdd.n172 vdd.n175 0.3365
R290 vdd.n169 vdd.n172 0.3365
R291 vdd.n166 vdd.n169 0.3365
R292 vdd.n163 vdd.n166 0.3365
R293 vdd.n160 vdd.n163 0.3365
R294 vdd.n157 vdd.n160 0.3365
R295 vdd.n154 vdd.n157 0.3365
R296 vdd.n151 vdd.n154 0.3365
R297 vdd.n148 vdd.n151 0.3365
R298 vdd.n145 vdd.n148 0.3365
R299 vdd.n142 vdd.n145 0.3365
R300 vdd.n139 vdd.n142 0.3365
R301 vdd.n138 vdd.n139 0.2135
R302 vdd.n137 vdd.n138 6.6485
R303 vdd.n182 vdd.t308 333.337
R304 vdd.t308 vdd.t310 259.26
R305 vdd.t310 vdd.t312 259.26
R306 vdd.t312 vdd.t314 259.26
R307 vdd.t314 vdd.t316 259.26
R308 vdd.t316 vdd.t318 259.26
R309 vdd.t318 vdd.t320 259.26
R310 vdd.t320 vdd.t322 259.26
R311 vdd.t322 vdd.t326 259.26
R312 vdd.t326 vdd.t324 259.26
R313 vdd.t324 vdd.t52 259.26
R314 vdd.t52 vdd.t50 259.26
R315 vdd.t50 vdd.t18 259.26
R316 vdd.t18 vdd.t16 259.26
R317 vdd.t16 vdd.t36 259.26
R318 vdd.t36 vdd.t34 259.26
R319 vdd.t66 vdd.t34 259.26
R320 vdd.t64 vdd.t66 259.26
R321 vdd.t82 vdd.t64 259.26
R322 vdd.t80 vdd.t82 259.26
R323 vdd.t85 vdd.t80 259.26
R324 vdd.t72 vdd.t85 259.26
R325 vdd.t70 vdd.t72 259.26
R326 vdd.t87 vdd.t70 259.26
R327 vdd.t126 vdd.t87 259.26
R328 vdd.t104 vdd.t126 259.26
R329 vdd.t102 vdd.t104 259.26
R330 vdd.t76 vdd.t102 259.26
R331 vdd.t74 vdd.t76 259.26
R332 vdd.t78 vdd.t74 259.26
R333 vdd.n138 vdd.t78 448.94
R334 vdd.n182 vdd.t309 4.34469
R335 vdd.n182 vdd.t328 4.34469
R336 vdd.n181 vdd.n179 5.36093
R337 vdd.n181 vdd.n180 5.36093
R338 vdd.n180 vdd.t311 1.4923
R339 vdd.n180 vdd.t313 2.06607
R340 vdd.n179 vdd.t329 1.4923
R341 vdd.n179 vdd.t330 2.06607
R342 vdd.n178 vdd.n176 5.36093
R343 vdd.n178 vdd.n177 5.36093
R344 vdd.n177 vdd.t315 1.4923
R345 vdd.n177 vdd.t317 2.06607
R346 vdd.n176 vdd.t331 1.4923
R347 vdd.n176 vdd.t332 2.06607
R348 vdd.n175 vdd.n173 5.36093
R349 vdd.n175 vdd.n174 5.36093
R350 vdd.n174 vdd.t319 1.4923
R351 vdd.n174 vdd.t321 2.06607
R352 vdd.n173 vdd.t333 1.4923
R353 vdd.n173 vdd.t334 2.06607
R354 vdd.n172 vdd.n170 5.36093
R355 vdd.n172 vdd.n171 5.36093
R356 vdd.n171 vdd.t323 1.4923
R357 vdd.n171 vdd.t327 2.06607
R358 vdd.n170 vdd.t335 1.4923
R359 vdd.n170 vdd.t336 2.06607
R360 vdd.n169 vdd.n167 2.85289
R361 vdd.n169 vdd.n168 2.85289
R362 vdd.n168 vdd.t325 1.4923
R363 vdd.n168 vdd.t294 2.06607
R364 vdd.n167 vdd.t337 1.4923
R365 vdd.n167 vdd.t53 2.06607
R366 vdd.n166 vdd.n164 5.28659
R367 vdd.n166 vdd.n165 5.28659
R368 vdd.n165 vdd.t69 1.4923
R369 vdd.n165 vdd.t68 2.06607
R370 vdd.n164 vdd.t51 1.4923
R371 vdd.n164 vdd.t19 2.06607
R372 vdd.n163 vdd.n161 5.28659
R373 vdd.n163 vdd.n162 5.28659
R374 vdd.n162 vdd.t125 1.4923
R375 vdd.n162 vdd.t124 2.06607
R376 vdd.n161 vdd.t17 1.4923
R377 vdd.n161 vdd.t37 2.06607
R378 vdd.n160 vdd.n158 5.28659
R379 vdd.n160 vdd.n159 5.28659
R380 vdd.n159 vdd.t101 1.4923
R381 vdd.n159 vdd.t100 2.06607
R382 vdd.n158 vdd.t35 1.4923
R383 vdd.n158 vdd.t67 2.06607
R384 vdd.n157 vdd.n155 5.28659
R385 vdd.n157 vdd.n156 5.28659
R386 vdd.n156 vdd.t265 1.4923
R387 vdd.n156 vdd.t264 2.06607
R388 vdd.n155 vdd.t65 1.4923
R389 vdd.n155 vdd.t83 2.06607
R390 vdd.n154 vdd.n152 5.28659
R391 vdd.n154 vdd.n153 5.28659
R392 vdd.n153 vdd.t296 1.4923
R393 vdd.n153 vdd.t295 2.06607
R394 vdd.n152 vdd.t81 1.4923
R395 vdd.n152 vdd.t86 2.06607
R396 vdd.n151 vdd.n149 5.28659
R397 vdd.n151 vdd.n150 5.28659
R398 vdd.n150 vdd.t73 1.4923
R399 vdd.n150 vdd.t71 2.06607
R400 vdd.n149 vdd.t84 1.4923
R401 vdd.n149 vdd.t89 2.06607
R402 vdd.n148 vdd.n146 5.28659
R403 vdd.n148 vdd.n147 5.28659
R404 vdd.n147 vdd.t128 1.4923
R405 vdd.n147 vdd.t127 2.06607
R406 vdd.n146 vdd.t88 1.4923
R407 vdd.n146 vdd.t183 2.06607
R408 vdd.n145 vdd.n143 5.28659
R409 vdd.n145 vdd.n144 5.28659
R410 vdd.n144 vdd.t105 1.4923
R411 vdd.n144 vdd.t103 2.06607
R412 vdd.n143 vdd.t182 1.4923
R413 vdd.n143 vdd.t171 2.06607
R414 vdd.n142 vdd.n140 5.28659
R415 vdd.n142 vdd.n141 5.28659
R416 vdd.n141 vdd.t77 1.4923
R417 vdd.n141 vdd.t75 2.06607
R418 vdd.n140 vdd.t170 1.4923
R419 vdd.n140 vdd.t157 2.06607
R420 vdd.n139 vdd.t79 4.34469
R421 vdd.n139 vdd.t156 4.34469
R422 vdd.n135 vdd.n136 0.3215
R423 vdd.n132 vdd.n135 0.3365
R424 vdd.n129 vdd.n132 0.3365
R425 vdd.n126 vdd.n129 0.3365
R426 vdd.n123 vdd.n126 0.3365
R427 vdd.n120 vdd.n123 0.3365
R428 vdd.n117 vdd.n120 0.3365
R429 vdd.n114 vdd.n117 0.3365
R430 vdd.n111 vdd.n114 0.3365
R431 vdd.n108 vdd.n111 0.3365
R432 vdd.n105 vdd.n108 0.3365
R433 vdd.n102 vdd.n105 0.3365
R434 vdd.n99 vdd.n102 0.3365
R435 vdd.n96 vdd.n99 0.3365
R436 vdd.n93 vdd.n96 0.3365
R437 vdd.n92 vdd.n93 0.2135
R438 vdd.n137 vdd.n92 4.8845
R439 vdd.n136 vdd.t215 333.337
R440 vdd.t215 vdd.t217 259.26
R441 vdd.t217 vdd.t219 259.26
R442 vdd.t219 vdd.t221 259.26
R443 vdd.t221 vdd.t223 259.26
R444 vdd.t223 vdd.t225 259.26
R445 vdd.t225 vdd.t227 259.26
R446 vdd.t227 vdd.t229 259.26
R447 vdd.t229 vdd.t231 259.26
R448 vdd.t231 vdd.t233 259.26
R449 vdd.t233 vdd.t110 259.26
R450 vdd.t110 vdd.t144 259.26
R451 vdd.t144 vdd.t142 259.26
R452 vdd.t142 vdd.t136 259.26
R453 vdd.t136 vdd.t134 259.26
R454 vdd.t134 vdd.t56 259.26
R455 vdd.t54 vdd.t56 259.26
R456 vdd.t22 vdd.t54 259.26
R457 vdd.t20 vdd.t22 259.26
R458 vdd.t40 vdd.t20 259.26
R459 vdd.t38 vdd.t40 259.26
R460 vdd.t2 vdd.t38 259.26
R461 vdd.t0 vdd.t2 259.26
R462 vdd.t10 vdd.t0 259.26
R463 vdd.t8 vdd.t10 259.26
R464 vdd.t6 vdd.t8 259.26
R465 vdd.t4 vdd.t6 259.26
R466 vdd.t14 vdd.t4 259.26
R467 vdd.t12 vdd.t14 259.26
R468 vdd.t32 vdd.t12 259.26
R469 vdd.n92 vdd.t32 448.94
R470 vdd.n136 vdd.t216 4.34469
R471 vdd.n136 vdd.t254 4.34469
R472 vdd.n135 vdd.n133 5.36093
R473 vdd.n135 vdd.n134 5.36093
R474 vdd.n134 vdd.t218 1.4923
R475 vdd.n134 vdd.t220 2.06607
R476 vdd.n133 vdd.t255 1.4923
R477 vdd.n133 vdd.t256 2.06607
R478 vdd.n132 vdd.n130 5.36093
R479 vdd.n132 vdd.n131 5.36093
R480 vdd.n131 vdd.t222 1.4923
R481 vdd.n131 vdd.t224 2.06607
R482 vdd.n130 vdd.t257 1.4923
R483 vdd.n130 vdd.t258 2.06607
R484 vdd.n129 vdd.n127 5.36093
R485 vdd.n129 vdd.n128 5.36093
R486 vdd.n128 vdd.t226 1.4923
R487 vdd.n128 vdd.t228 2.06607
R488 vdd.n127 vdd.t259 1.4923
R489 vdd.n127 vdd.t260 2.06607
R490 vdd.n126 vdd.n124 5.36093
R491 vdd.n126 vdd.n125 5.36093
R492 vdd.n125 vdd.t230 1.4923
R493 vdd.n125 vdd.t232 2.06607
R494 vdd.n124 vdd.t261 1.4923
R495 vdd.n124 vdd.t262 2.06607
R496 vdd.n123 vdd.n121 2.85289
R497 vdd.n123 vdd.n122 2.85289
R498 vdd.n122 vdd.t234 1.4923
R499 vdd.n122 vdd.t111 2.06607
R500 vdd.n121 vdd.t263 1.4923
R501 vdd.n121 vdd.t129 2.06607
R502 vdd.n120 vdd.n118 5.28659
R503 vdd.n120 vdd.n119 5.28659
R504 vdd.n119 vdd.t173 1.4923
R505 vdd.n119 vdd.t172 2.06607
R506 vdd.n118 vdd.t145 1.4923
R507 vdd.n118 vdd.t143 2.06607
R508 vdd.n117 vdd.n115 5.28659
R509 vdd.n117 vdd.n116 5.28659
R510 vdd.n116 vdd.t159 1.4923
R511 vdd.n116 vdd.t158 2.06607
R512 vdd.n115 vdd.t137 1.4923
R513 vdd.n115 vdd.t135 2.06607
R514 vdd.n114 vdd.n112 5.28659
R515 vdd.n114 vdd.n113 5.28659
R516 vdd.n113 vdd.t57 1.4923
R517 vdd.n113 vdd.t55 2.06607
R518 vdd.n112 vdd.t151 1.4923
R519 vdd.n112 vdd.t150 2.06607
R520 vdd.n111 vdd.n109 5.28659
R521 vdd.n111 vdd.n110 5.28659
R522 vdd.n110 vdd.t23 1.4923
R523 vdd.n110 vdd.t21 2.06607
R524 vdd.n109 vdd.t165 1.4923
R525 vdd.n109 vdd.t164 2.06607
R526 vdd.n108 vdd.n106 5.28659
R527 vdd.n108 vdd.n107 5.28659
R528 vdd.n107 vdd.t41 1.4923
R529 vdd.n107 vdd.t39 2.06607
R530 vdd.n106 vdd.t179 1.4923
R531 vdd.n106 vdd.t178 2.06607
R532 vdd.n105 vdd.n103 5.28659
R533 vdd.n105 vdd.n104 5.28659
R534 vdd.n104 vdd.t113 1.4923
R535 vdd.n104 vdd.t112 2.06607
R536 vdd.n103 vdd.t3 1.4923
R537 vdd.n103 vdd.t1 2.06607
R538 vdd.n102 vdd.n100 5.28659
R539 vdd.n102 vdd.n101 5.28659
R540 vdd.n101 vdd.t214 1.4923
R541 vdd.n101 vdd.t213 2.06607
R542 vdd.n100 vdd.t11 1.4923
R543 vdd.n100 vdd.t9 2.06607
R544 vdd.n99 vdd.n97 5.28659
R545 vdd.n99 vdd.n98 5.28659
R546 vdd.n98 vdd.t192 1.4923
R547 vdd.n98 vdd.t191 2.06607
R548 vdd.n97 vdd.t7 1.4923
R549 vdd.n97 vdd.t5 2.06607
R550 vdd.n96 vdd.n94 5.28659
R551 vdd.n96 vdd.n95 5.28659
R552 vdd.n95 vdd.t267 1.4923
R553 vdd.n95 vdd.t266 2.06607
R554 vdd.n94 vdd.t15 1.4923
R555 vdd.n94 vdd.t13 2.06607
R556 vdd.n93 vdd.t297 4.34469
R557 vdd.n93 vdd.t33 4.34469
R558 vdd.n89 vdd.n90 0.3215
R559 vdd.n86 vdd.n89 0.3365
R560 vdd.n83 vdd.n86 0.3365
R561 vdd.n80 vdd.n83 0.3365
R562 vdd.n77 vdd.n80 0.3365
R563 vdd.n74 vdd.n77 0.3365
R564 vdd.n71 vdd.n74 0.3365
R565 vdd.n68 vdd.n71 0.3365
R566 vdd.n65 vdd.n68 0.3365
R567 vdd.n62 vdd.n65 0.3365
R568 vdd.n59 vdd.n62 0.3365
R569 vdd.n56 vdd.n59 0.3365
R570 vdd.n53 vdd.n56 0.3365
R571 vdd.n50 vdd.n53 0.3365
R572 vdd.n47 vdd.n50 0.3365
R573 vdd.n46 vdd.n47 0.2135
R574 vdd.n91 vdd.n46 4.8845
R575 vdd.n90 vdd.t274 333.337
R576 vdd.t274 vdd.t276 259.26
R577 vdd.t276 vdd.t278 259.26
R578 vdd.t278 vdd.t280 259.26
R579 vdd.t280 vdd.t282 259.26
R580 vdd.t282 vdd.t284 259.26
R581 vdd.t284 vdd.t286 259.26
R582 vdd.t286 vdd.t288 259.26
R583 vdd.t288 vdd.t290 259.26
R584 vdd.t290 vdd.t292 259.26
R585 vdd.t292 vdd.t62 259.26
R586 vdd.t62 vdd.t30 259.26
R587 vdd.t30 vdd.t28 259.26
R588 vdd.t28 vdd.t48 259.26
R589 vdd.t48 vdd.t46 259.26
R590 vdd.t46 vdd.t187 259.26
R591 vdd.t185 vdd.t187 259.26
R592 vdd.t92 vdd.t185 259.26
R593 vdd.t90 vdd.t92 259.26
R594 vdd.t132 vdd.t90 259.26
R595 vdd.t130 vdd.t132 259.26
R596 vdd.t148 vdd.t130 259.26
R597 vdd.t146 vdd.t148 259.26
R598 vdd.t140 vdd.t146 259.26
R599 vdd.t138 vdd.t140 259.26
R600 vdd.t154 vdd.t138 259.26
R601 vdd.t152 vdd.t154 259.26
R602 vdd.t168 vdd.t152 259.26
R603 vdd.t166 vdd.t168 259.26
R604 vdd.t180 vdd.t166 259.26
R605 vdd.n46 vdd.t180 448.94
R606 vdd.n90 vdd.t275 4.34469
R607 vdd.n90 vdd.t298 4.34469
R608 vdd.n89 vdd.n87 5.36093
R609 vdd.n89 vdd.n88 5.36093
R610 vdd.n88 vdd.t277 1.4923
R611 vdd.n88 vdd.t279 2.06607
R612 vdd.n87 vdd.t299 1.4923
R613 vdd.n87 vdd.t300 2.06607
R614 vdd.n86 vdd.n84 5.36093
R615 vdd.n86 vdd.n85 5.36093
R616 vdd.n85 vdd.t281 1.4923
R617 vdd.n85 vdd.t283 2.06607
R618 vdd.n84 vdd.t301 1.4923
R619 vdd.n84 vdd.t302 2.06607
R620 vdd.n83 vdd.n81 5.36093
R621 vdd.n83 vdd.n82 5.36093
R622 vdd.n82 vdd.t285 1.4923
R623 vdd.n82 vdd.t287 2.06607
R624 vdd.n81 vdd.t303 1.4923
R625 vdd.n81 vdd.t304 2.06607
R626 vdd.n80 vdd.n78 5.36093
R627 vdd.n80 vdd.n79 5.36093
R628 vdd.n79 vdd.t289 1.4923
R629 vdd.n79 vdd.t291 2.06607
R630 vdd.n78 vdd.t305 1.4923
R631 vdd.n78 vdd.t306 2.06607
R632 vdd.n77 vdd.n75 2.85289
R633 vdd.n77 vdd.n76 2.85289
R634 vdd.n76 vdd.t293 1.4923
R635 vdd.n76 vdd.t338 2.06607
R636 vdd.n75 vdd.t307 1.4923
R637 vdd.n75 vdd.t63 2.06607
R638 vdd.n74 vdd.n72 5.28659
R639 vdd.n74 vdd.n73 5.28659
R640 vdd.n73 vdd.t269 1.4923
R641 vdd.n73 vdd.t268 2.06607
R642 vdd.n72 vdd.t31 1.4923
R643 vdd.n72 vdd.t29 2.06607
R644 vdd.n71 vdd.n69 5.28659
R645 vdd.n71 vdd.n70 5.28659
R646 vdd.n70 vdd.t355 1.4923
R647 vdd.n70 vdd.t354 2.06607
R648 vdd.n69 vdd.t49 1.4923
R649 vdd.n69 vdd.t47 2.06607
R650 vdd.n68 vdd.n66 5.28659
R651 vdd.n68 vdd.n67 5.28659
R652 vdd.n67 vdd.t236 1.4923
R653 vdd.n67 vdd.t235 2.06607
R654 vdd.n66 vdd.t188 1.4923
R655 vdd.n66 vdd.t186 2.06607
R656 vdd.n65 vdd.n63 5.28659
R657 vdd.n65 vdd.n64 5.28659
R658 vdd.n64 vdd.t95 1.4923
R659 vdd.n64 vdd.t94 2.06607
R660 vdd.n63 vdd.t93 1.4923
R661 vdd.n63 vdd.t91 2.06607
R662 vdd.n62 vdd.n60 5.28659
R663 vdd.n62 vdd.n61 5.28659
R664 vdd.n61 vdd.t340 1.4923
R665 vdd.n61 vdd.t339 2.06607
R666 vdd.n60 vdd.t133 1.4923
R667 vdd.n60 vdd.t131 2.06607
R668 vdd.n59 vdd.n57 5.28659
R669 vdd.n59 vdd.n58 5.28659
R670 vdd.n58 vdd.t271 1.4923
R671 vdd.n58 vdd.t270 2.06607
R672 vdd.n57 vdd.t149 1.4923
R673 vdd.n57 vdd.t147 2.06607
R674 vdd.n56 vdd.n54 5.28659
R675 vdd.n56 vdd.n55 5.28659
R676 vdd.n55 vdd.t190 1.4923
R677 vdd.n55 vdd.t189 2.06607
R678 vdd.n54 vdd.t141 1.4923
R679 vdd.n54 vdd.t139 2.06607
R680 vdd.n53 vdd.n51 5.28659
R681 vdd.n53 vdd.n52 5.28659
R682 vdd.n52 vdd.t357 1.4923
R683 vdd.n52 vdd.t356 2.06607
R684 vdd.n51 vdd.t155 1.4923
R685 vdd.n51 vdd.t153 2.06607
R686 vdd.n50 vdd.n48 5.28659
R687 vdd.n50 vdd.n49 5.28659
R688 vdd.n49 vdd.t238 1.4923
R689 vdd.n49 vdd.t237 2.06607
R690 vdd.n48 vdd.t169 1.4923
R691 vdd.n48 vdd.t167 2.06607
R692 vdd.n47 vdd.t184 4.34469
R693 vdd.n47 vdd.t181 4.34469
R694 vdd.n43 vdd.n44 0.3215
R695 vdd.n40 vdd.n43 0.3365
R696 vdd.n37 vdd.n40 0.3365
R697 vdd.n34 vdd.n37 0.3365
R698 vdd.n31 vdd.n34 0.3365
R699 vdd.n28 vdd.n31 0.3365
R700 vdd.n25 vdd.n28 0.3365
R701 vdd.n22 vdd.n25 0.3365
R702 vdd.n19 vdd.n22 0.3365
R703 vdd.n16 vdd.n19 0.3365
R704 vdd.n13 vdd.n16 0.3365
R705 vdd.n10 vdd.n13 0.3365
R706 vdd.n7 vdd.n10 0.3365
R707 vdd.n4 vdd.n7 0.3365
R708 vdd.n1 vdd.n4 0.3365
R709 vdd.n0 vdd.n1 0.2135
R710 vdd.n45 vdd.n0 4.8845
R711 vdd.n44 vdd.t193 333.337
R712 vdd.t193 vdd.t195 259.26
R713 vdd.t195 vdd.t197 259.26
R714 vdd.t197 vdd.t199 259.26
R715 vdd.t199 vdd.t201 259.26
R716 vdd.t201 vdd.t203 259.26
R717 vdd.t203 vdd.t205 259.26
R718 vdd.t205 vdd.t207 259.26
R719 vdd.t207 vdd.t209 259.26
R720 vdd.t209 vdd.t211 259.26
R721 vdd.t211 vdd.t114 259.26
R722 vdd.t114 vdd.t176 259.26
R723 vdd.t176 vdd.t174 259.26
R724 vdd.t174 vdd.t162 259.26
R725 vdd.t162 vdd.t160 259.26
R726 vdd.t160 vdd.t60 259.26
R727 vdd.t58 vdd.t60 259.26
R728 vdd.t26 vdd.t58 259.26
R729 vdd.t24 vdd.t26 259.26
R730 vdd.t44 vdd.t24 259.26
R731 vdd.t42 vdd.t44 259.26
R732 vdd.t98 vdd.t42 259.26
R733 vdd.t96 vdd.t98 259.26
R734 vdd.t242 vdd.t96 259.26
R735 vdd.t240 vdd.t242 259.26
R736 vdd.t250 vdd.t240 259.26
R737 vdd.t248 vdd.t250 259.26
R738 vdd.t122 vdd.t248 259.26
R739 vdd.t120 vdd.t122 259.26
R740 vdd.t108 vdd.t120 259.26
R741 vdd.n0 vdd.t108 448.94
R742 vdd.n44 vdd.t343 4.34469
R743 vdd.n44 vdd.t194 4.34469
R744 vdd.n43 vdd.n41 5.36093
R745 vdd.n43 vdd.n42 5.36093
R746 vdd.n42 vdd.t344 1.4923
R747 vdd.n42 vdd.t345 2.06607
R748 vdd.n41 vdd.t196 1.4923
R749 vdd.n41 vdd.t198 2.06607
R750 vdd.n40 vdd.n38 5.36093
R751 vdd.n40 vdd.n39 5.36093
R752 vdd.n39 vdd.t346 1.4923
R753 vdd.n39 vdd.t347 2.06607
R754 vdd.n38 vdd.t200 1.4923
R755 vdd.n38 vdd.t202 2.06607
R756 vdd.n37 vdd.n35 5.36093
R757 vdd.n37 vdd.n36 5.36093
R758 vdd.n36 vdd.t348 1.4923
R759 vdd.n36 vdd.t349 2.06607
R760 vdd.n35 vdd.t204 1.4923
R761 vdd.n35 vdd.t206 2.06607
R762 vdd.n34 vdd.n32 5.36093
R763 vdd.n34 vdd.n33 5.36093
R764 vdd.n33 vdd.t350 1.4923
R765 vdd.n33 vdd.t352 2.06607
R766 vdd.n32 vdd.t208 1.4923
R767 vdd.n32 vdd.t210 2.06607
R768 vdd.n31 vdd.n29 2.85289
R769 vdd.n31 vdd.n30 2.85289
R770 vdd.n30 vdd.t351 1.4923
R771 vdd.n30 vdd.t353 2.06607
R772 vdd.n29 vdd.t212 1.4923
R773 vdd.n29 vdd.t115 2.06607
R774 vdd.n28 vdd.n26 5.28659
R775 vdd.n28 vdd.n27 5.28659
R776 vdd.n27 vdd.t359 1.4923
R777 vdd.n27 vdd.t358 2.06607
R778 vdd.n26 vdd.t177 1.4923
R779 vdd.n26 vdd.t175 2.06607
R780 vdd.n25 vdd.n23 5.28659
R781 vdd.n25 vdd.n24 5.28659
R782 vdd.n24 vdd.t247 1.4923
R783 vdd.n24 vdd.t246 2.06607
R784 vdd.n23 vdd.t163 1.4923
R785 vdd.n23 vdd.t161 2.06607
R786 vdd.n22 vdd.n20 5.28659
R787 vdd.n22 vdd.n21 5.28659
R788 vdd.n21 vdd.t245 1.4923
R789 vdd.n21 vdd.t244 2.06607
R790 vdd.n20 vdd.t61 1.4923
R791 vdd.n20 vdd.t59 2.06607
R792 vdd.n19 vdd.n17 5.28659
R793 vdd.n19 vdd.n18 5.28659
R794 vdd.n18 vdd.t117 1.4923
R795 vdd.n18 vdd.t116 2.06607
R796 vdd.n17 vdd.t27 1.4923
R797 vdd.n17 vdd.t25 2.06607
R798 vdd.n16 vdd.n14 5.28659
R799 vdd.n16 vdd.n15 5.28659
R800 vdd.n15 vdd.t107 1.4923
R801 vdd.n15 vdd.t106 2.06607
R802 vdd.n14 vdd.t45 1.4923
R803 vdd.n14 vdd.t43 2.06607
R804 vdd.n13 vdd.n11 5.28659
R805 vdd.n13 vdd.n12 5.28659
R806 vdd.n12 vdd.t119 1.4923
R807 vdd.n12 vdd.t118 2.06607
R808 vdd.n11 vdd.t99 1.4923
R809 vdd.n11 vdd.t97 2.06607
R810 vdd.n10 vdd.n8 5.28659
R811 vdd.n10 vdd.n9 5.28659
R812 vdd.n9 vdd.t243 1.4923
R813 vdd.n9 vdd.t241 2.06607
R814 vdd.n8 vdd.t342 1.4923
R815 vdd.n8 vdd.t341 2.06607
R816 vdd.n7 vdd.n5 5.28659
R817 vdd.n7 vdd.n6 5.28659
R818 vdd.n6 vdd.t251 1.4923
R819 vdd.n6 vdd.t249 2.06607
R820 vdd.n5 vdd.t273 1.4923
R821 vdd.n5 vdd.t272 2.06607
R822 vdd.n4 vdd.n2 5.28659
R823 vdd.n4 vdd.n3 5.28659
R824 vdd.n3 vdd.t123 1.4923
R825 vdd.n3 vdd.t121 2.06607
R826 vdd.n2 vdd.t253 1.4923
R827 vdd.n2 vdd.t252 2.06607
R828 vdd.n1 vdd.t109 4.34469
R829 vdd.n1 vdd.t239 4.34469
R830 vss.n2 vss.n1 4.5005
R831 vss.n4 vss.n3 4.5005
R832 vss.n6 vss.n5 4.5005
R833 vss.n8 vss.n7 4.5005
R834 vss.n10 vss.n9 4.5005
R835 vss.n12 vss.n11 4.5005
R836 vss.n14 vss.n13 4.5005
R837 vss.n16 vss.n15 4.5005
R838 vss.n18 vss.n17 4.5005
R839 vss.n20 vss.n19 4.5005
R840 vss.n22 vss.n21 4.5005
R841 vss.n24 vss.n23 4.5005
R842 vss.n26 vss.n25 4.5005
R843 vss.n28 vss.n27 4.5005
R844 vss.n30 vss.n29 4.5005
R845 vss.n248 vss.n247 4.5005
R846 vss vss.n248 0.1211
R847 vss.n248 vss.n30 0.9005
R848 vss.n30 vss.n28 0.9005
R849 vss.n28 vss.n26 0.9005
R850 vss.n26 vss.n24 0.9005
R851 vss.n24 vss.n22 0.9005
R852 vss.n22 vss.n20 0.9005
R853 vss.n20 vss.n18 0.9005
R854 vss.n18 vss.n16 0.9005
R855 vss.n16 vss.n14 0.9005
R856 vss.n14 vss.n12 0.9005
R857 vss.n12 vss.n10 0.9005
R858 vss.n10 vss.n8 0.9005
R859 vss.n8 vss.n6 0.9005
R860 vss.n6 vss.n4 0.9005
R861 vss.n4 vss.n2 0.9005
R862 vss.n2 vss.n0 1.7175
R863 vss.n247 vss.n29 2.2505
R864 vss.n29 vss.n27 2.2505
R865 vss.n27 vss.n25 2.2505
R866 vss.n25 vss.n23 2.2505
R867 vss.n23 vss.n21 2.2505
R868 vss.n21 vss.n19 2.2505
R869 vss.n19 vss.n17 2.2505
R870 vss.n17 vss.n15 2.2505
R871 vss.n15 vss.n13 2.2505
R872 vss.n13 vss.n11 2.2505
R873 vss.n11 vss.n9 2.2505
R874 vss.n9 vss.n7 2.2505
R875 vss.n7 vss.n5 2.2505
R876 vss.n5 vss.n3 2.2505
R877 vss.n3 vss.n1 2.2505
R878 vss.n1 vss.n31 0.5
R879 vss.n31 vss.n0 3.44375
R880 vss.n0 vss.n246 5.20787
R881 vss.n246 vss.n34 1.7645
R882 vss.n34 vss.n33 1.7645
R883 vss.n33 vss.n32 1.7645
R884 vss.n64 vss.n65 0.3365
R885 vss.n62 vss.n64 0.3365
R886 vss.n60 vss.n62 0.3365
R887 vss.n58 vss.n60 0.3365
R888 vss.n56 vss.n58 0.3365
R889 vss.n54 vss.n56 0.3365
R890 vss.n52 vss.n54 0.3365
R891 vss.n50 vss.n52 0.3365
R892 vss.n48 vss.n50 0.3365
R893 vss.n46 vss.n48 0.3365
R894 vss.n44 vss.n46 0.3365
R895 vss.n42 vss.n44 0.3365
R896 vss.n40 vss.n42 0.3365
R897 vss.n38 vss.n40 0.3365
R898 vss.n36 vss.n38 0.3365
R899 vss.n35 vss.n36 0.1985
R900 vss.n246 vss.n35 5.1095
R901 vss.n65 vss.n245 5.46026
R902 vss.n244 vss.n245 648.691
R903 vss.n245 vss.t346 969.759
R904 vss.t346 vss.t348 733.871
R905 vss.t348 vss.t344 733.871
R906 vss.t344 vss.t350 733.871
R907 vss.t350 vss.t352 733.871
R908 vss.t352 vss.t356 733.871
R909 vss.t356 vss.t358 733.871
R910 vss.t358 vss.t360 733.871
R911 vss.t360 vss.t354 733.871
R912 vss.t354 vss.t362 733.871
R913 vss.t362 vss.t61 733.871
R914 vss.t61 vss.t59 733.871
R915 vss.t59 vss.t20 733.871
R916 vss.t20 vss.t18 733.871
R917 vss.t18 vss.t39 733.871
R918 vss.t39 vss.t37 733.871
R919 vss.t115 vss.t37 733.871
R920 vss.t113 vss.t115 733.871
R921 vss.t324 vss.t113 733.871
R922 vss.t322 vss.t324 733.871
R923 vss.t273 vss.t322 733.871
R924 vss.t271 vss.t273 733.871
R925 vss.t289 vss.t271 733.871
R926 vss.t287 vss.t289 733.871
R927 vss.t191 vss.t287 733.871
R928 vss.t189 vss.t191 733.871
R929 vss.t119 vss.t189 733.871
R930 vss.t117 vss.t119 733.871
R931 vss.t328 vss.t117 733.871
R932 vss.t326 vss.t328 733.871
R933 vss.n66 vss.t326 1231.85
R934 vss.n66 vss.n67 5643.3
R935 vss.n67 vss.n68 4574.51
R936 vss.n68 vss.n69 4574.51
R937 vss.n70 vss.n244 30.1382
R938 vss.n70 vss.t371 45.0548
R939 vss.t371 vss.t373 34.0957
R940 vss.t373 vss.t375 34.0957
R941 vss.t375 vss.t377 34.0957
R942 vss.t377 vss.t379 34.0957
R943 vss.t379 vss.t381 34.0957
R944 vss.t381 vss.t383 34.0957
R945 vss.t383 vss.t385 34.0957
R946 vss.t385 vss.t387 34.0957
R947 vss.t387 vss.t389 34.0957
R948 vss.t389 vss.t235 34.0957
R949 vss.t235 vss.t233 34.0957
R950 vss.t233 vss.t231 34.0957
R951 vss.t231 vss.t225 34.0957
R952 vss.t225 vss.t223 34.0957
R953 vss.t223 vss.t239 34.0957
R954 vss.t237 vss.t239 34.0957
R955 vss.t281 vss.t237 34.0957
R956 vss.t279 vss.t281 34.0957
R957 vss.t229 vss.t279 34.0957
R958 vss.t227 vss.t229 34.0957
R959 vss.t285 vss.t227 34.0957
R960 vss.t283 vss.t285 34.0957
R961 vss.t366 vss.t283 34.0957
R962 vss.t364 vss.t366 34.0957
R963 vss.t165 vss.t364 34.0957
R964 vss.t163 vss.t165 34.0957
R965 vss.t131 vss.t163 34.0957
R966 vss.t129 vss.t131 34.0957
R967 vss.t391 vss.t129 34.0957
R968 vss.n71 vss.t391 57.2317
R969 vss.n71 vss.n69 3662.5
R970 vss.n247 vss.t1 1782.98
R971 vss.t1 vss.t0 19.0962
R972 vss.t0 vss.n244 2097.97
R973 vss.n244 vss.n103 914.063
R974 vss.n103 vss.t175 1366.48
R975 vss.t175 vss.t177 1034.09
R976 vss.t177 vss.t179 1034.09
R977 vss.t179 vss.t181 1034.09
R978 vss.t181 vss.t183 1034.09
R979 vss.t183 vss.t171 1034.09
R980 vss.t171 vss.t173 1034.09
R981 vss.t173 vss.t167 1034.09
R982 vss.t167 vss.t169 1034.09
R983 vss.t169 vss.t185 1034.09
R984 vss.t185 vss.t213 1034.09
R985 vss.t213 vss.t127 1034.09
R986 vss.t127 vss.t125 1034.09
R987 vss.t125 vss.t332 1034.09
R988 vss.t332 vss.t330 1034.09
R989 vss.t330 vss.t140 1034.09
R990 vss.t138 vss.t140 1034.09
R991 vss.t153 vss.t138 1034.09
R992 vss.t151 vss.t153 1034.09
R993 vss.t147 vss.t151 1034.09
R994 vss.t145 vss.t147 1034.09
R995 vss.t67 vss.t145 1034.09
R996 vss.t65 vss.t67 1034.09
R997 vss.t30 vss.t65 1034.09
R998 vss.t28 vss.t30 1034.09
R999 vss.t51 vss.t28 1034.09
R1000 vss.t49 vss.t51 1034.09
R1001 vss.t123 vss.t49 1034.09
R1002 vss.t121 vss.t123 1034.09
R1003 vss.t263 vss.t121 1034.09
R1004 vss.n104 vss.t263 1735.8
R1005 vss.n104 vss.n69 914.063
R1006 vss.n244 vss.n150 914.063
R1007 vss.n150 vss.t243 1366.48
R1008 vss.t243 vss.t245 1034.09
R1009 vss.t245 vss.t247 1034.09
R1010 vss.t247 vss.t249 1034.09
R1011 vss.t249 vss.t251 1034.09
R1012 vss.t251 vss.t253 1034.09
R1013 vss.t253 vss.t255 1034.09
R1014 vss.t255 vss.t257 1034.09
R1015 vss.t257 vss.t259 1034.09
R1016 vss.t259 vss.t261 1034.09
R1017 vss.t261 vss.t22 1034.09
R1018 vss.t22 vss.t43 1034.09
R1019 vss.t43 vss.t41 1034.09
R1020 vss.t41 vss.t55 1034.09
R1021 vss.t55 vss.t53 1034.09
R1022 vss.t53 vss.t75 1034.09
R1023 vss.t73 vss.t75 1034.09
R1024 vss.t83 vss.t73 1034.09
R1025 vss.t81 vss.t83 1034.09
R1026 vss.t87 vss.t81 1034.09
R1027 vss.t85 vss.t87 1034.09
R1028 vss.t91 vss.t85 1034.09
R1029 vss.t89 vss.t91 1034.09
R1030 vss.t105 vss.t89 1034.09
R1031 vss.t103 vss.t105 1034.09
R1032 vss.t95 vss.t103 1034.09
R1033 vss.t93 vss.t95 1034.09
R1034 vss.t99 vss.t93 1034.09
R1035 vss.t97 vss.t99 1034.09
R1036 vss.t101 vss.t97 1034.09
R1037 vss.n151 vss.t101 1735.8
R1038 vss.n151 vss.n67 914.063
R1039 vss.n244 vss.n197 914.063
R1040 vss.n197 vss.t203 1366.48
R1041 vss.t203 vss.t205 1034.09
R1042 vss.t205 vss.t195 1034.09
R1043 vss.t195 vss.t197 1034.09
R1044 vss.t197 vss.t207 1034.09
R1045 vss.t207 vss.t199 1034.09
R1046 vss.t199 vss.t209 1034.09
R1047 vss.t209 vss.t193 1034.09
R1048 vss.t193 vss.t211 1034.09
R1049 vss.t211 vss.t201 1034.09
R1050 vss.t201 vss.t155 1034.09
R1051 vss.t155 vss.t4 1034.09
R1052 vss.t4 vss.t2 1034.09
R1053 vss.t2 vss.t12 1034.09
R1054 vss.t12 vss.t10 1034.09
R1055 vss.t10 vss.t8 1034.09
R1056 vss.t6 vss.t8 1034.09
R1057 vss.t16 vss.t6 1034.09
R1058 vss.t14 vss.t16 1034.09
R1059 vss.t35 vss.t14 1034.09
R1060 vss.t33 vss.t35 1034.09
R1061 vss.t26 vss.t33 1034.09
R1062 vss.t24 vss.t26 1034.09
R1063 vss.t47 vss.t24 1034.09
R1064 vss.t45 vss.t47 1034.09
R1065 vss.t109 vss.t45 1034.09
R1066 vss.t107 vss.t109 1034.09
R1067 vss.t79 vss.t107 1034.09
R1068 vss.t77 vss.t79 1034.09
R1069 vss.t111 vss.t77 1034.09
R1070 vss.n198 vss.t111 1735.8
R1071 vss.n198 vss.n68 914.063
R1072 vss.n199 vss.n198 2.66271
R1073 vss.n242 vss.n243 0.3365
R1074 vss.n239 vss.n242 0.3365
R1075 vss.n236 vss.n239 0.3365
R1076 vss.n233 vss.n236 0.3365
R1077 vss.n230 vss.n233 0.3365
R1078 vss.n227 vss.n230 0.3365
R1079 vss.n224 vss.n227 0.3365
R1080 vss.n221 vss.n224 0.3365
R1081 vss.n218 vss.n221 0.3365
R1082 vss.n215 vss.n218 0.3365
R1083 vss.n212 vss.n215 0.3365
R1084 vss.n209 vss.n212 0.3365
R1085 vss.n206 vss.n209 0.3365
R1086 vss.n203 vss.n206 0.3365
R1087 vss.n200 vss.n203 0.3365
R1088 vss.n199 vss.n200 0.1985
R1089 vss.n33 vss.n199 5.1095
R1090 vss.n243 vss.n197 2.80071
R1091 vss.n243 vss.t312 8.51132
R1092 vss.n243 vss.t204 8.51132
R1093 vss.n242 vss.n240 6.49224
R1094 vss.n242 vss.n241 6.49224
R1095 vss.n241 vss.t313 1.99806
R1096 vss.n241 vss.t314 1.99806
R1097 vss.n240 vss.t206 1.99806
R1098 vss.n240 vss.t196 1.99806
R1099 vss.n239 vss.n237 6.49224
R1100 vss.n239 vss.n238 6.49224
R1101 vss.n238 vss.t315 1.99806
R1102 vss.n238 vss.t316 1.99806
R1103 vss.n237 vss.t198 1.99806
R1104 vss.n237 vss.t208 1.99806
R1105 vss.n236 vss.n234 6.49224
R1106 vss.n236 vss.n235 6.49224
R1107 vss.n235 vss.t317 1.99806
R1108 vss.n235 vss.t318 1.99806
R1109 vss.n234 vss.t200 1.99806
R1110 vss.n234 vss.t210 1.99806
R1111 vss.n233 vss.n231 6.49224
R1112 vss.n233 vss.n232 6.49224
R1113 vss.n232 vss.t319 1.99806
R1114 vss.n232 vss.t320 1.99806
R1115 vss.n231 vss.t194 1.99806
R1116 vss.n231 vss.t212 1.99806
R1117 vss.n230 vss.n228 6.49224
R1118 vss.n230 vss.n229 6.49224
R1119 vss.n229 vss.t321 1.99806
R1120 vss.n229 vss.t156 1.99806
R1121 vss.n228 vss.t202 1.99806
R1122 vss.n228 vss.t267 1.99806
R1123 vss.n227 vss.n225 6.35874
R1124 vss.n227 vss.n226 6.35874
R1125 vss.n226 vss.t5 1.99806
R1126 vss.n226 vss.t3 1.99806
R1127 vss.n225 vss.t309 1.99806
R1128 vss.n225 vss.t308 1.99806
R1129 vss.n224 vss.n222 6.35874
R1130 vss.n224 vss.n223 6.35874
R1131 vss.n223 vss.t13 1.99806
R1132 vss.n223 vss.t11 1.99806
R1133 vss.n222 vss.t136 1.99806
R1134 vss.n222 vss.t135 1.99806
R1135 vss.n221 vss.n219 6.35874
R1136 vss.n221 vss.n220 6.35874
R1137 vss.n220 vss.t9 1.99806
R1138 vss.n220 vss.t7 1.99806
R1139 vss.n219 vss.t150 1.99806
R1140 vss.n219 vss.t149 1.99806
R1141 vss.n218 vss.n216 6.35874
R1142 vss.n218 vss.n217 6.35874
R1143 vss.n217 vss.t17 1.99806
R1144 vss.n217 vss.t15 1.99806
R1145 vss.n216 vss.t144 1.99806
R1146 vss.n216 vss.t143 1.99806
R1147 vss.n215 vss.n213 6.35874
R1148 vss.n215 vss.n214 6.35874
R1149 vss.n214 vss.t36 1.99806
R1150 vss.n214 vss.t34 1.99806
R1151 vss.n213 vss.t64 1.99806
R1152 vss.n213 vss.t63 1.99806
R1153 vss.n212 vss.n210 6.35874
R1154 vss.n212 vss.n211 6.35874
R1155 vss.n211 vss.t72 1.99806
R1156 vss.n211 vss.t71 1.99806
R1157 vss.n210 vss.t27 1.99806
R1158 vss.n210 vss.t25 1.99806
R1159 vss.n209 vss.n207 6.35874
R1160 vss.n209 vss.n208 6.35874
R1161 vss.n208 vss.t58 1.99806
R1162 vss.n208 vss.t57 1.99806
R1163 vss.n207 vss.t48 1.99806
R1164 vss.n207 vss.t46 1.99806
R1165 vss.n206 vss.n204 6.35874
R1166 vss.n206 vss.n205 6.35874
R1167 vss.n205 vss.t110 1.99806
R1168 vss.n205 vss.t108 1.99806
R1169 vss.n204 vss.t292 1.99806
R1170 vss.n204 vss.t291 1.99806
R1171 vss.n203 vss.n201 6.35874
R1172 vss.n203 vss.n202 6.35874
R1173 vss.n202 vss.t80 1.99806
R1174 vss.n202 vss.t78 1.99806
R1175 vss.n201 vss.t294 1.99806
R1176 vss.n201 vss.t293 1.99806
R1177 vss.n200 vss.t112 8.51132
R1178 vss.n200 vss.t137 8.51132
R1179 vss.n152 vss.n151 2.66271
R1180 vss.n195 vss.n196 0.3365
R1181 vss.n192 vss.n195 0.3365
R1182 vss.n189 vss.n192 0.3365
R1183 vss.n186 vss.n189 0.3365
R1184 vss.n183 vss.n186 0.3365
R1185 vss.n180 vss.n183 0.3365
R1186 vss.n177 vss.n180 0.3365
R1187 vss.n174 vss.n177 0.3365
R1188 vss.n171 vss.n174 0.3365
R1189 vss.n168 vss.n171 0.3365
R1190 vss.n165 vss.n168 0.3365
R1191 vss.n162 vss.n165 0.3365
R1192 vss.n159 vss.n162 0.3365
R1193 vss.n156 vss.n159 0.3365
R1194 vss.n153 vss.n156 0.3365
R1195 vss.n152 vss.n153 0.1985
R1196 vss.n34 vss.n152 5.1095
R1197 vss.n196 vss.n150 2.80071
R1198 vss.n196 vss.t244 8.51132
R1199 vss.n196 vss.t334 8.51132
R1200 vss.n195 vss.n193 6.49224
R1201 vss.n195 vss.n194 6.49224
R1202 vss.n194 vss.t246 1.99806
R1203 vss.n194 vss.t248 1.99806
R1204 vss.n193 vss.t335 1.99806
R1205 vss.n193 vss.t339 1.99806
R1206 vss.n192 vss.n190 6.49224
R1207 vss.n192 vss.n191 6.49224
R1208 vss.n191 vss.t250 1.99806
R1209 vss.n191 vss.t252 1.99806
R1210 vss.n190 vss.t340 1.99806
R1211 vss.n190 vss.t341 1.99806
R1212 vss.n189 vss.n187 6.49224
R1213 vss.n189 vss.n188 6.49224
R1214 vss.n188 vss.t254 1.99806
R1215 vss.n188 vss.t256 1.99806
R1216 vss.n187 vss.t337 1.99806
R1217 vss.n187 vss.t338 1.99806
R1218 vss.n186 vss.n184 6.49224
R1219 vss.n186 vss.n185 6.49224
R1220 vss.n185 vss.t258 1.99806
R1221 vss.n185 vss.t260 1.99806
R1222 vss.n184 vss.t342 1.99806
R1223 vss.n184 vss.t336 1.99806
R1224 vss.n183 vss.n181 6.49224
R1225 vss.n183 vss.n182 6.49224
R1226 vss.n182 vss.t262 1.99806
R1227 vss.n182 vss.t32 1.99806
R1228 vss.n181 vss.t343 1.99806
R1229 vss.n181 vss.t23 1.99806
R1230 vss.n180 vss.n178 6.35874
R1231 vss.n180 vss.n179 6.35874
R1232 vss.n179 vss.t70 1.99806
R1233 vss.n179 vss.t69 1.99806
R1234 vss.n178 vss.t44 1.99806
R1235 vss.n178 vss.t42 1.99806
R1236 vss.n177 vss.n175 6.35874
R1237 vss.n177 vss.n176 6.35874
R1238 vss.n176 vss.t56 1.99806
R1239 vss.n176 vss.t54 1.99806
R1240 vss.n175 vss.t160 1.99806
R1241 vss.n175 vss.t159 1.99806
R1242 vss.n174 vss.n172 6.35874
R1243 vss.n174 vss.n173 6.35874
R1244 vss.n173 vss.t76 1.99806
R1245 vss.n173 vss.t74 1.99806
R1246 vss.n172 vss.t218 1.99806
R1247 vss.n172 vss.t217 1.99806
R1248 vss.n171 vss.n169 6.35874
R1249 vss.n171 vss.n170 6.35874
R1250 vss.n170 vss.t84 1.99806
R1251 vss.n170 vss.t82 1.99806
R1252 vss.n169 vss.t220 1.99806
R1253 vss.n169 vss.t219 1.99806
R1254 vss.n168 vss.n166 6.35874
R1255 vss.n168 vss.n167 6.35874
R1256 vss.n167 vss.t88 1.99806
R1257 vss.n167 vss.t86 1.99806
R1258 vss.n166 vss.t134 1.99806
R1259 vss.n166 vss.t133 1.99806
R1260 vss.n165 vss.n163 6.35874
R1261 vss.n165 vss.n164 6.35874
R1262 vss.n164 vss.t92 1.99806
R1263 vss.n164 vss.t90 1.99806
R1264 vss.n163 vss.t222 1.99806
R1265 vss.n163 vss.t221 1.99806
R1266 vss.n162 vss.n160 6.35874
R1267 vss.n162 vss.n161 6.35874
R1268 vss.n161 vss.t106 1.99806
R1269 vss.n161 vss.t104 1.99806
R1270 vss.n160 vss.t188 1.99806
R1271 vss.n160 vss.t187 1.99806
R1272 vss.n159 vss.n157 6.35874
R1273 vss.n159 vss.n158 6.35874
R1274 vss.n158 vss.t96 1.99806
R1275 vss.n158 vss.t94 1.99806
R1276 vss.n157 vss.t162 1.99806
R1277 vss.n157 vss.t161 1.99806
R1278 vss.n156 vss.n154 6.35874
R1279 vss.n156 vss.n155 6.35874
R1280 vss.n155 vss.t100 1.99806
R1281 vss.n155 vss.t98 1.99806
R1282 vss.n154 vss.t266 1.99806
R1283 vss.n154 vss.t265 1.99806
R1284 vss.n153 vss.t102 8.51132
R1285 vss.n153 vss.t307 8.51132
R1286 vss.n105 vss.n104 2.66271
R1287 vss.n148 vss.n149 0.3365
R1288 vss.n145 vss.n148 0.3365
R1289 vss.n142 vss.n145 0.3365
R1290 vss.n139 vss.n142 0.3365
R1291 vss.n136 vss.n139 0.3365
R1292 vss.n133 vss.n136 0.3365
R1293 vss.n130 vss.n133 0.3365
R1294 vss.n127 vss.n130 0.3365
R1295 vss.n124 vss.n127 0.3365
R1296 vss.n121 vss.n124 0.3365
R1297 vss.n118 vss.n121 0.3365
R1298 vss.n115 vss.n118 0.3365
R1299 vss.n112 vss.n115 0.3365
R1300 vss.n109 vss.n112 0.3365
R1301 vss.n106 vss.n109 0.3365
R1302 vss.n105 vss.n106 0.1985
R1303 vss.n32 vss.n105 5.1095
R1304 vss.n149 vss.n103 2.80071
R1305 vss.n149 vss.t176 8.51132
R1306 vss.n149 vss.t295 8.51132
R1307 vss.n148 vss.n146 6.49224
R1308 vss.n148 vss.n147 6.49224
R1309 vss.n147 vss.t178 1.99806
R1310 vss.n147 vss.t180 1.99806
R1311 vss.n146 vss.t296 1.99806
R1312 vss.n146 vss.t297 1.99806
R1313 vss.n145 vss.n143 6.49224
R1314 vss.n145 vss.n144 6.49224
R1315 vss.n144 vss.t182 1.99806
R1316 vss.n144 vss.t184 1.99806
R1317 vss.n143 vss.t298 1.99806
R1318 vss.n143 vss.t299 1.99806
R1319 vss.n142 vss.n140 6.49224
R1320 vss.n142 vss.n141 6.49224
R1321 vss.n141 vss.t172 1.99806
R1322 vss.n141 vss.t174 1.99806
R1323 vss.n140 vss.t300 1.99806
R1324 vss.n140 vss.t301 1.99806
R1325 vss.n139 vss.n137 6.49224
R1326 vss.n139 vss.n138 6.49224
R1327 vss.n138 vss.t168 1.99806
R1328 vss.n138 vss.t170 1.99806
R1329 vss.n137 vss.t302 1.99806
R1330 vss.n137 vss.t303 1.99806
R1331 vss.n136 vss.n134 6.49224
R1332 vss.n136 vss.n135 6.49224
R1333 vss.n135 vss.t186 1.99806
R1334 vss.n135 vss.t214 1.99806
R1335 vss.n134 vss.t304 1.99806
R1336 vss.n134 vss.t268 1.99806
R1337 vss.n133 vss.n131 6.35874
R1338 vss.n133 vss.n132 6.35874
R1339 vss.n132 vss.t128 1.99806
R1340 vss.n132 vss.t126 1.99806
R1341 vss.n131 vss.t311 1.99806
R1342 vss.n131 vss.t310 1.99806
R1343 vss.n130 vss.n128 6.35874
R1344 vss.n130 vss.n129 6.35874
R1345 vss.n129 vss.t370 1.99806
R1346 vss.n129 vss.t369 1.99806
R1347 vss.n128 vss.t333 1.99806
R1348 vss.n128 vss.t331 1.99806
R1349 vss.n127 vss.n125 6.35874
R1350 vss.n127 vss.n126 6.35874
R1351 vss.n126 vss.t276 1.99806
R1352 vss.n126 vss.t275 1.99806
R1353 vss.n125 vss.t141 1.99806
R1354 vss.n125 vss.t139 1.99806
R1355 vss.n124 vss.n122 6.35874
R1356 vss.n124 vss.n123 6.35874
R1357 vss.n123 vss.t242 1.99806
R1358 vss.n123 vss.t241 1.99806
R1359 vss.n122 vss.t154 1.99806
R1360 vss.n122 vss.t152 1.99806
R1361 vss.n121 vss.n119 6.35874
R1362 vss.n121 vss.n120 6.35874
R1363 vss.n120 vss.t216 1.99806
R1364 vss.n120 vss.t215 1.99806
R1365 vss.n119 vss.t148 1.99806
R1366 vss.n119 vss.t146 1.99806
R1367 vss.n118 vss.n116 6.35874
R1368 vss.n118 vss.n117 6.35874
R1369 vss.n117 vss.t158 1.99806
R1370 vss.n117 vss.t157 1.99806
R1371 vss.n116 vss.t68 1.99806
R1372 vss.n116 vss.t66 1.99806
R1373 vss.n115 vss.n113 6.35874
R1374 vss.n115 vss.n114 6.35874
R1375 vss.n114 vss.t306 1.99806
R1376 vss.n114 vss.t305 1.99806
R1377 vss.n113 vss.t31 1.99806
R1378 vss.n113 vss.t29 1.99806
R1379 vss.n112 vss.n110 6.35874
R1380 vss.n112 vss.n111 6.35874
R1381 vss.n111 vss.t278 1.99806
R1382 vss.n111 vss.t277 1.99806
R1383 vss.n110 vss.t52 1.99806
R1384 vss.n110 vss.t50 1.99806
R1385 vss.n109 vss.n107 6.35874
R1386 vss.n109 vss.n108 6.35874
R1387 vss.n108 vss.t270 1.99806
R1388 vss.n108 vss.t269 1.99806
R1389 vss.n107 vss.t124 1.99806
R1390 vss.n107 vss.t122 1.99806
R1391 vss.n106 vss.t264 8.51132
R1392 vss.n106 vss.t368 8.51132
R1393 vss.n102 vss.n71 5.32359
R1394 vss.n74 vss.n72 0.3365
R1395 vss.n76 vss.n74 0.3365
R1396 vss.n78 vss.n76 0.3365
R1397 vss.n80 vss.n78 0.3365
R1398 vss.n82 vss.n80 0.3365
R1399 vss.n84 vss.n82 0.3365
R1400 vss.n86 vss.n84 0.3365
R1401 vss.n88 vss.n86 0.3365
R1402 vss.n90 vss.n88 0.3365
R1403 vss.n92 vss.n90 0.3365
R1404 vss.n94 vss.n92 0.3365
R1405 vss.n96 vss.n94 0.3365
R1406 vss.n98 vss.n96 0.3365
R1407 vss.n100 vss.n98 0.3365
R1408 vss.n101 vss.n100 0.3365
R1409 vss.n102 vss.n101 0.1985
R1410 vss.n32 vss.n102 6.8735
R1411 vss.n101 vss.t392 8.51132
R1412 vss.n100 vss.n99 6.35874
R1413 vss.n99 vss.t132 1.99806
R1414 vss.n99 vss.t130 1.99806
R1415 vss.n98 vss.n97 6.35874
R1416 vss.n97 vss.t166 1.99806
R1417 vss.n97 vss.t164 1.99806
R1418 vss.n96 vss.n95 6.35874
R1419 vss.n95 vss.t367 1.99806
R1420 vss.n95 vss.t365 1.99806
R1421 vss.n94 vss.n93 6.35874
R1422 vss.n93 vss.t286 1.99806
R1423 vss.n93 vss.t284 1.99806
R1424 vss.n92 vss.n91 6.35874
R1425 vss.n91 vss.t230 1.99806
R1426 vss.n91 vss.t228 1.99806
R1427 vss.n90 vss.n89 6.35874
R1428 vss.n89 vss.t282 1.99806
R1429 vss.n89 vss.t280 1.99806
R1430 vss.n88 vss.n87 6.35874
R1431 vss.n87 vss.t240 1.99806
R1432 vss.n87 vss.t238 1.99806
R1433 vss.n86 vss.n85 6.35874
R1434 vss.n85 vss.t226 1.99806
R1435 vss.n85 vss.t224 1.99806
R1436 vss.n84 vss.n83 6.35874
R1437 vss.n83 vss.t234 1.99806
R1438 vss.n83 vss.t232 1.99806
R1439 vss.n82 vss.n81 6.49224
R1440 vss.n81 vss.t390 1.99806
R1441 vss.n81 vss.t236 1.99806
R1442 vss.n80 vss.n79 6.49224
R1443 vss.n79 vss.t386 1.99806
R1444 vss.n79 vss.t388 1.99806
R1445 vss.n78 vss.n77 6.49224
R1446 vss.n77 vss.t382 1.99806
R1447 vss.n77 vss.t384 1.99806
R1448 vss.n76 vss.n75 6.49224
R1449 vss.n75 vss.t378 1.99806
R1450 vss.n75 vss.t380 1.99806
R1451 vss.n74 vss.n73 6.49224
R1452 vss.n73 vss.t374 1.99806
R1453 vss.n73 vss.t376 1.99806
R1454 vss.n72 vss.t372 8.51132
R1455 vss.n72 vss.n70 5.46159
R1456 vss.n35 vss.n66 5.32226
R1457 vss.n65 vss.t347 8.51132
R1458 vss.n64 vss.n63 6.49224
R1459 vss.n63 vss.t349 1.99806
R1460 vss.n63 vss.t345 1.99806
R1461 vss.n62 vss.n61 6.49224
R1462 vss.n61 vss.t351 1.99806
R1463 vss.n61 vss.t353 1.99806
R1464 vss.n60 vss.n59 6.49224
R1465 vss.n59 vss.t357 1.99806
R1466 vss.n59 vss.t359 1.99806
R1467 vss.n58 vss.n57 6.49224
R1468 vss.n57 vss.t361 1.99806
R1469 vss.n57 vss.t355 1.99806
R1470 vss.n56 vss.n55 6.49224
R1471 vss.n55 vss.t363 1.99806
R1472 vss.n55 vss.t62 1.99806
R1473 vss.n54 vss.n53 6.35874
R1474 vss.n53 vss.t60 1.99806
R1475 vss.n53 vss.t21 1.99806
R1476 vss.n52 vss.n51 6.35874
R1477 vss.n51 vss.t19 1.99806
R1478 vss.n51 vss.t40 1.99806
R1479 vss.n50 vss.n49 6.35874
R1480 vss.n49 vss.t38 1.99806
R1481 vss.n49 vss.t116 1.99806
R1482 vss.n48 vss.n47 6.35874
R1483 vss.n47 vss.t114 1.99806
R1484 vss.n47 vss.t325 1.99806
R1485 vss.n46 vss.n45 6.35874
R1486 vss.n45 vss.t323 1.99806
R1487 vss.n45 vss.t274 1.99806
R1488 vss.n44 vss.n43 6.35874
R1489 vss.n43 vss.t272 1.99806
R1490 vss.n43 vss.t290 1.99806
R1491 vss.n42 vss.n41 6.35874
R1492 vss.n41 vss.t288 1.99806
R1493 vss.n41 vss.t192 1.99806
R1494 vss.n40 vss.n39 6.35874
R1495 vss.n39 vss.t190 1.99806
R1496 vss.n39 vss.t120 1.99806
R1497 vss.n38 vss.n37 6.35874
R1498 vss.n37 vss.t118 1.99806
R1499 vss.n37 vss.t329 1.99806
R1500 vss.n36 vss.t327 8.51132
R1501 vss.n31 vss.t142 26.9484
R1502 a_33552_472.n0 a_33552_472.t8 1.4923
R1503 a_33552_472.t9 a_33552_472.n0 2.06607
R1504 a_33552_472.n37 a_33552_472.n8 0.109291
R1505 a_33552_472.n16 a_33552_472.n37 0.156764
R1506 a_33552_472.n0 a_33552_472.n16 2.66577
R1507 a_33552_472.n8 a_33552_472.n38 6.41071
R1508 a_33552_472.n38 a_33552_472.t18 1.99806
R1509 a_33552_472.n38 a_33552_472.t19 1.99806
R1510 a_33552_472.n37 a_33552_472.n36 2.7371
R1511 a_33552_472.n36 a_33552_472.t35 13.4447
R1512 a_33552_472.n36 a_33552_472.t55 15.8415
R1513 a_33552_472.n36 a_33552_472.n20 10.5449
R1514 a_33552_472.n36 a_33552_472.n35 10.5449
R1515 a_33552_472.n35 a_33552_472.t34 13.4447
R1516 a_33552_472.n35 a_33552_472.t54 15.8415
R1517 a_33552_472.n35 a_33552_472.n34 10.5449
R1518 a_33552_472.n34 a_33552_472.t33 13.4447
R1519 a_33552_472.n34 a_33552_472.t53 15.8415
R1520 a_33552_472.n34 a_33552_472.n33 10.5449
R1521 a_33552_472.n33 a_33552_472.t32 13.4447
R1522 a_33552_472.n33 a_33552_472.t52 15.8415
R1523 a_33552_472.n33 a_33552_472.n32 10.5449
R1524 a_33552_472.n32 a_33552_472.t31 13.4447
R1525 a_33552_472.n32 a_33552_472.t51 15.8415
R1526 a_33552_472.n32 a_33552_472.n31 10.5449
R1527 a_33552_472.n31 a_33552_472.t30 13.4447
R1528 a_33552_472.n31 a_33552_472.t50 15.8415
R1529 a_33552_472.n31 a_33552_472.n30 10.5449
R1530 a_33552_472.n30 a_33552_472.t29 13.4447
R1531 a_33552_472.n30 a_33552_472.t49 15.8415
R1532 a_33552_472.n30 a_33552_472.n29 10.5449
R1533 a_33552_472.n29 a_33552_472.t28 13.4447
R1534 a_33552_472.n29 a_33552_472.t48 15.8415
R1535 a_33552_472.n29 a_33552_472.n28 10.5449
R1536 a_33552_472.n28 a_33552_472.t27 13.4447
R1537 a_33552_472.n28 a_33552_472.t47 15.8415
R1538 a_33552_472.n28 a_33552_472.n27 10.5449
R1539 a_33552_472.n27 a_33552_472.t26 13.4447
R1540 a_33552_472.n27 a_33552_472.t46 15.8415
R1541 a_33552_472.n27 a_33552_472.n26 10.5449
R1542 a_33552_472.n26 a_33552_472.t25 13.4447
R1543 a_33552_472.n26 a_33552_472.t45 15.8415
R1544 a_33552_472.n26 a_33552_472.n25 10.5449
R1545 a_33552_472.n25 a_33552_472.t24 13.4447
R1546 a_33552_472.n25 a_33552_472.t44 15.8415
R1547 a_33552_472.n25 a_33552_472.n24 10.5449
R1548 a_33552_472.n24 a_33552_472.t23 13.4447
R1549 a_33552_472.n24 a_33552_472.t43 15.8415
R1550 a_33552_472.n24 a_33552_472.n23 10.5449
R1551 a_33552_472.n23 a_33552_472.t22 13.4447
R1552 a_33552_472.n23 a_33552_472.t42 15.8415
R1553 a_33552_472.n23 a_33552_472.n22 10.5449
R1554 a_33552_472.n22 a_33552_472.t21 13.4447
R1555 a_33552_472.n22 a_33552_472.t41 15.8415
R1556 a_33552_472.n22 a_33552_472.n21 10.5449
R1557 a_33552_472.n21 a_33552_472.t20 14.7952
R1558 a_33552_472.n21 a_33552_472.t40 16.2795
R1559 a_33552_472.n20 a_33552_472.t36 13.4447
R1560 a_33552_472.n20 a_33552_472.t56 15.8415
R1561 a_33552_472.n20 a_33552_472.n19 10.5449
R1562 a_33552_472.n19 a_33552_472.t37 13.4447
R1563 a_33552_472.n19 a_33552_472.t57 15.8415
R1564 a_33552_472.n19 a_33552_472.n18 10.5449
R1565 a_33552_472.n18 a_33552_472.t38 13.4447
R1566 a_33552_472.n18 a_33552_472.t58 15.8415
R1567 a_33552_472.n18 a_33552_472.n17 10.5449
R1568 a_33552_472.n17 a_33552_472.t39 13.4447
R1569 a_33552_472.n17 a_33552_472.t59 15.8415
R1570 a_33552_472.n12 a_33552_472.n14 0.877022
R1571 a_33552_472.n10 a_33552_472.n12 0.877022
R1572 a_33552_472.n16 a_33552_472.n10 0.832022
R1573 a_33552_472.n14 a_33552_472.n15 3.52202
R1574 a_33552_472.n15 a_33552_472.t0 2.06607
R1575 a_33552_472.n15 a_33552_472.t1 1.4923
R1576 a_33552_472.n14 a_33552_472.n13 2.68463
R1577 a_33552_472.n13 a_33552_472.t2 1.4923
R1578 a_33552_472.n13 a_33552_472.t3 2.06607
R1579 a_33552_472.n12 a_33552_472.n11 2.68463
R1580 a_33552_472.n11 a_33552_472.t4 1.4923
R1581 a_33552_472.n11 a_33552_472.t5 2.06607
R1582 a_33552_472.n10 a_33552_472.n9 2.68463
R1583 a_33552_472.n9 a_33552_472.t6 1.4923
R1584 a_33552_472.n9 a_33552_472.t7 2.06607
R1585 a_33552_472.n5 a_33552_472.n3 0.877022
R1586 a_33552_472.n7 a_33552_472.n5 0.877022
R1587 a_33552_472.n8 a_33552_472.n7 0.792891
R1588 a_33552_472.n7 a_33552_472.n6 6.4355
R1589 a_33552_472.n6 a_33552_472.t16 1.99806
R1590 a_33552_472.n6 a_33552_472.t17 1.99806
R1591 a_33552_472.n5 a_33552_472.n4 6.4355
R1592 a_33552_472.n4 a_33552_472.t14 1.99806
R1593 a_33552_472.n4 a_33552_472.t15 1.99806
R1594 a_33552_472.n3 a_33552_472.n2 6.4355
R1595 a_33552_472.n2 a_33552_472.t12 1.99806
R1596 a_33552_472.n2 a_33552_472.t13 1.99806
R1597 a_33552_472.n3 a_33552_472.n1 7.31202
R1598 a_33552_472.n1 a_33552_472.t10 1.99806
R1599 a_33552_472.n1 a_33552_472.t11 1.99806
R1600 a_33552_852.n0 a_33552_852.t8 1.4923
R1601 a_33552_852.t9 a_33552_852.n0 2.06607
R1602 a_33552_852.n0 a_33552_852.n8 2.66577
R1603 a_33552_852.n8 a_33552_852.n37 0.156764
R1604 a_33552_852.n37 a_33552_852.n16 0.109291
R1605 a_33552_852.n16 a_33552_852.n38 6.41071
R1606 a_33552_852.n38 a_33552_852.t18 1.99806
R1607 a_33552_852.n38 a_33552_852.t19 1.99806
R1608 a_33552_852.n37 a_33552_852.n36 2.7371
R1609 a_33552_852.n36 a_33552_852.t35 15.8415
R1610 a_33552_852.n36 a_33552_852.t55 13.4447
R1611 a_33552_852.n36 a_33552_852.n20 10.5449
R1612 a_33552_852.n36 a_33552_852.n35 10.5449
R1613 a_33552_852.n35 a_33552_852.t34 15.8415
R1614 a_33552_852.n35 a_33552_852.t54 13.4447
R1615 a_33552_852.n35 a_33552_852.n34 10.5449
R1616 a_33552_852.n34 a_33552_852.t33 15.8415
R1617 a_33552_852.n34 a_33552_852.t53 13.4447
R1618 a_33552_852.n34 a_33552_852.n33 10.5449
R1619 a_33552_852.n33 a_33552_852.t32 15.8415
R1620 a_33552_852.n33 a_33552_852.t52 13.4447
R1621 a_33552_852.n33 a_33552_852.n32 10.5449
R1622 a_33552_852.n32 a_33552_852.t31 15.8415
R1623 a_33552_852.n32 a_33552_852.t51 13.4447
R1624 a_33552_852.n32 a_33552_852.n31 10.5449
R1625 a_33552_852.n31 a_33552_852.t30 15.8415
R1626 a_33552_852.n31 a_33552_852.t50 13.4447
R1627 a_33552_852.n31 a_33552_852.n30 10.5449
R1628 a_33552_852.n30 a_33552_852.t29 15.8415
R1629 a_33552_852.n30 a_33552_852.t49 13.4447
R1630 a_33552_852.n30 a_33552_852.n29 10.5449
R1631 a_33552_852.n29 a_33552_852.t28 15.8415
R1632 a_33552_852.n29 a_33552_852.t48 13.4447
R1633 a_33552_852.n29 a_33552_852.n28 10.5449
R1634 a_33552_852.n28 a_33552_852.t27 15.8415
R1635 a_33552_852.n28 a_33552_852.t47 13.4447
R1636 a_33552_852.n28 a_33552_852.n27 10.5449
R1637 a_33552_852.n27 a_33552_852.t26 15.8415
R1638 a_33552_852.n27 a_33552_852.t46 13.4447
R1639 a_33552_852.n27 a_33552_852.n26 10.5449
R1640 a_33552_852.n26 a_33552_852.t25 15.8415
R1641 a_33552_852.n26 a_33552_852.t45 13.4447
R1642 a_33552_852.n26 a_33552_852.n25 10.5449
R1643 a_33552_852.n25 a_33552_852.t24 15.8415
R1644 a_33552_852.n25 a_33552_852.t44 13.4447
R1645 a_33552_852.n25 a_33552_852.n24 10.5449
R1646 a_33552_852.n24 a_33552_852.t23 15.8415
R1647 a_33552_852.n24 a_33552_852.t43 13.4447
R1648 a_33552_852.n24 a_33552_852.n23 10.5449
R1649 a_33552_852.n23 a_33552_852.t22 15.8415
R1650 a_33552_852.n23 a_33552_852.t42 13.4447
R1651 a_33552_852.n23 a_33552_852.n22 10.5449
R1652 a_33552_852.n22 a_33552_852.t21 15.8415
R1653 a_33552_852.n22 a_33552_852.t41 13.4447
R1654 a_33552_852.n22 a_33552_852.n21 10.5449
R1655 a_33552_852.n21 a_33552_852.t20 16.2795
R1656 a_33552_852.n21 a_33552_852.t40 14.7952
R1657 a_33552_852.n20 a_33552_852.t36 15.8415
R1658 a_33552_852.n20 a_33552_852.t56 13.4447
R1659 a_33552_852.n20 a_33552_852.n19 10.5449
R1660 a_33552_852.n19 a_33552_852.t37 15.8415
R1661 a_33552_852.n19 a_33552_852.t57 13.4447
R1662 a_33552_852.n19 a_33552_852.n18 10.5449
R1663 a_33552_852.n18 a_33552_852.t38 15.8415
R1664 a_33552_852.n18 a_33552_852.t58 13.4447
R1665 a_33552_852.n18 a_33552_852.n17 10.5449
R1666 a_33552_852.n17 a_33552_852.t39 15.8415
R1667 a_33552_852.n17 a_33552_852.t59 13.4447
R1668 a_33552_852.n12 a_33552_852.n14 0.877022
R1669 a_33552_852.n10 a_33552_852.n12 0.877022
R1670 a_33552_852.n16 a_33552_852.n10 0.792891
R1671 a_33552_852.n14 a_33552_852.n15 7.31202
R1672 a_33552_852.n15 a_33552_852.t10 1.99806
R1673 a_33552_852.n15 a_33552_852.t11 1.99806
R1674 a_33552_852.n14 a_33552_852.n13 6.4355
R1675 a_33552_852.n13 a_33552_852.t12 1.99806
R1676 a_33552_852.n13 a_33552_852.t13 1.99806
R1677 a_33552_852.n12 a_33552_852.n11 6.4355
R1678 a_33552_852.n11 a_33552_852.t14 1.99806
R1679 a_33552_852.n11 a_33552_852.t15 1.99806
R1680 a_33552_852.n10 a_33552_852.n9 6.4355
R1681 a_33552_852.n9 a_33552_852.t16 1.99806
R1682 a_33552_852.n9 a_33552_852.t17 1.99806
R1683 a_33552_852.n5 a_33552_852.n3 0.877022
R1684 a_33552_852.n7 a_33552_852.n5 0.877022
R1685 a_33552_852.n8 a_33552_852.n7 0.832022
R1686 a_33552_852.n7 a_33552_852.n6 2.68463
R1687 a_33552_852.n6 a_33552_852.t6 1.4923
R1688 a_33552_852.n6 a_33552_852.t7 2.06607
R1689 a_33552_852.n5 a_33552_852.n4 2.68463
R1690 a_33552_852.n4 a_33552_852.t4 1.4923
R1691 a_33552_852.n4 a_33552_852.t5 2.06607
R1692 a_33552_852.n3 a_33552_852.n2 2.68463
R1693 a_33552_852.n2 a_33552_852.t2 1.4923
R1694 a_33552_852.n2 a_33552_852.t3 2.06607
R1695 a_33552_852.n3 a_33552_852.n1 3.52202
R1696 a_33552_852.n1 a_33552_852.t0 2.06607
R1697 a_33552_852.n1 a_33552_852.t1 1.4923
R1698 a_33552_2040.n0 a_33552_2040.t8 1.4923
R1699 a_33552_2040.t9 a_33552_2040.n0 2.06607
R1700 a_33552_2040.n37 a_33552_2040.n8 0.109291
R1701 a_33552_2040.n16 a_33552_2040.n37 0.156764
R1702 a_33552_2040.n0 a_33552_2040.n16 2.66577
R1703 a_33552_2040.n8 a_33552_2040.n38 6.41071
R1704 a_33552_2040.n38 a_33552_2040.t18 1.99806
R1705 a_33552_2040.n38 a_33552_2040.t19 1.99806
R1706 a_33552_2040.n37 a_33552_2040.n36 2.7371
R1707 a_33552_2040.n36 a_33552_2040.t35 13.4447
R1708 a_33552_2040.n36 a_33552_2040.t55 15.8415
R1709 a_33552_2040.n36 a_33552_2040.n20 10.5449
R1710 a_33552_2040.n36 a_33552_2040.n35 10.5449
R1711 a_33552_2040.n35 a_33552_2040.t34 13.4447
R1712 a_33552_2040.n35 a_33552_2040.t54 15.8415
R1713 a_33552_2040.n35 a_33552_2040.n34 10.5449
R1714 a_33552_2040.n34 a_33552_2040.t33 13.4447
R1715 a_33552_2040.n34 a_33552_2040.t53 15.8415
R1716 a_33552_2040.n34 a_33552_2040.n33 10.5449
R1717 a_33552_2040.n33 a_33552_2040.t32 13.4447
R1718 a_33552_2040.n33 a_33552_2040.t52 15.8415
R1719 a_33552_2040.n33 a_33552_2040.n32 10.5449
R1720 a_33552_2040.n32 a_33552_2040.t31 13.4447
R1721 a_33552_2040.n32 a_33552_2040.t51 15.8415
R1722 a_33552_2040.n32 a_33552_2040.n31 10.5449
R1723 a_33552_2040.n31 a_33552_2040.t30 13.4447
R1724 a_33552_2040.n31 a_33552_2040.t50 15.8415
R1725 a_33552_2040.n31 a_33552_2040.n30 10.5449
R1726 a_33552_2040.n30 a_33552_2040.t29 13.4447
R1727 a_33552_2040.n30 a_33552_2040.t49 15.8415
R1728 a_33552_2040.n30 a_33552_2040.n29 10.5449
R1729 a_33552_2040.n29 a_33552_2040.t28 13.4447
R1730 a_33552_2040.n29 a_33552_2040.t48 15.8415
R1731 a_33552_2040.n29 a_33552_2040.n28 10.5449
R1732 a_33552_2040.n28 a_33552_2040.t27 13.4447
R1733 a_33552_2040.n28 a_33552_2040.t47 15.8415
R1734 a_33552_2040.n28 a_33552_2040.n27 10.5449
R1735 a_33552_2040.n27 a_33552_2040.t26 13.4447
R1736 a_33552_2040.n27 a_33552_2040.t46 15.8415
R1737 a_33552_2040.n27 a_33552_2040.n26 10.5449
R1738 a_33552_2040.n26 a_33552_2040.t25 13.4447
R1739 a_33552_2040.n26 a_33552_2040.t45 15.8415
R1740 a_33552_2040.n26 a_33552_2040.n25 10.5449
R1741 a_33552_2040.n25 a_33552_2040.t24 13.4447
R1742 a_33552_2040.n25 a_33552_2040.t44 15.8415
R1743 a_33552_2040.n25 a_33552_2040.n24 10.5449
R1744 a_33552_2040.n24 a_33552_2040.t23 13.4447
R1745 a_33552_2040.n24 a_33552_2040.t43 15.8415
R1746 a_33552_2040.n24 a_33552_2040.n23 10.5449
R1747 a_33552_2040.n23 a_33552_2040.t22 13.4447
R1748 a_33552_2040.n23 a_33552_2040.t42 15.8415
R1749 a_33552_2040.n23 a_33552_2040.n22 10.5449
R1750 a_33552_2040.n22 a_33552_2040.t21 13.4447
R1751 a_33552_2040.n22 a_33552_2040.t41 15.8415
R1752 a_33552_2040.n22 a_33552_2040.n21 10.5449
R1753 a_33552_2040.n21 a_33552_2040.t20 14.7952
R1754 a_33552_2040.n21 a_33552_2040.t40 16.2795
R1755 a_33552_2040.n20 a_33552_2040.t36 13.4447
R1756 a_33552_2040.n20 a_33552_2040.t56 15.8415
R1757 a_33552_2040.n20 a_33552_2040.n19 10.5449
R1758 a_33552_2040.n19 a_33552_2040.t37 13.4447
R1759 a_33552_2040.n19 a_33552_2040.t57 15.8415
R1760 a_33552_2040.n19 a_33552_2040.n18 10.5449
R1761 a_33552_2040.n18 a_33552_2040.t38 13.4447
R1762 a_33552_2040.n18 a_33552_2040.t58 15.8415
R1763 a_33552_2040.n18 a_33552_2040.n17 10.5449
R1764 a_33552_2040.n17 a_33552_2040.t39 13.4447
R1765 a_33552_2040.n17 a_33552_2040.t59 15.8415
R1766 a_33552_2040.n12 a_33552_2040.n14 0.877022
R1767 a_33552_2040.n10 a_33552_2040.n12 0.877022
R1768 a_33552_2040.n16 a_33552_2040.n10 0.832022
R1769 a_33552_2040.n14 a_33552_2040.n15 3.52202
R1770 a_33552_2040.n15 a_33552_2040.t0 2.06607
R1771 a_33552_2040.n15 a_33552_2040.t1 1.4923
R1772 a_33552_2040.n14 a_33552_2040.n13 2.68463
R1773 a_33552_2040.n13 a_33552_2040.t2 1.4923
R1774 a_33552_2040.n13 a_33552_2040.t3 2.06607
R1775 a_33552_2040.n12 a_33552_2040.n11 2.68463
R1776 a_33552_2040.n11 a_33552_2040.t4 1.4923
R1777 a_33552_2040.n11 a_33552_2040.t5 2.06607
R1778 a_33552_2040.n10 a_33552_2040.n9 2.68463
R1779 a_33552_2040.n9 a_33552_2040.t6 1.4923
R1780 a_33552_2040.n9 a_33552_2040.t7 2.06607
R1781 a_33552_2040.n5 a_33552_2040.n3 0.877022
R1782 a_33552_2040.n7 a_33552_2040.n5 0.877022
R1783 a_33552_2040.n8 a_33552_2040.n7 0.792891
R1784 a_33552_2040.n7 a_33552_2040.n6 6.4355
R1785 a_33552_2040.n6 a_33552_2040.t16 1.99806
R1786 a_33552_2040.n6 a_33552_2040.t17 1.99806
R1787 a_33552_2040.n5 a_33552_2040.n4 6.4355
R1788 a_33552_2040.n4 a_33552_2040.t14 1.99806
R1789 a_33552_2040.n4 a_33552_2040.t15 1.99806
R1790 a_33552_2040.n3 a_33552_2040.n2 6.4355
R1791 a_33552_2040.n2 a_33552_2040.t12 1.99806
R1792 a_33552_2040.n2 a_33552_2040.t13 1.99806
R1793 a_33552_2040.n3 a_33552_2040.n1 7.31202
R1794 a_33552_2040.n1 a_33552_2040.t10 1.99806
R1795 a_33552_2040.n1 a_33552_2040.t11 1.99806
R1796 a_33552_2420.n0 a_33552_2420.t8 1.4923
R1797 a_33552_2420.t9 a_33552_2420.n0 2.06607
R1798 a_33552_2420.n0 a_33552_2420.n8 2.66577
R1799 a_33552_2420.n8 a_33552_2420.n37 0.156764
R1800 a_33552_2420.n37 a_33552_2420.n16 0.109291
R1801 a_33552_2420.n16 a_33552_2420.n38 6.41071
R1802 a_33552_2420.n38 a_33552_2420.t18 1.99806
R1803 a_33552_2420.n38 a_33552_2420.t19 1.99806
R1804 a_33552_2420.n37 a_33552_2420.n36 2.7371
R1805 a_33552_2420.n36 a_33552_2420.t35 15.8415
R1806 a_33552_2420.n36 a_33552_2420.t55 13.4447
R1807 a_33552_2420.n36 a_33552_2420.n20 10.5449
R1808 a_33552_2420.n36 a_33552_2420.n35 10.5449
R1809 a_33552_2420.n35 a_33552_2420.t34 15.8415
R1810 a_33552_2420.n35 a_33552_2420.t54 13.4447
R1811 a_33552_2420.n35 a_33552_2420.n34 10.5449
R1812 a_33552_2420.n34 a_33552_2420.t33 15.8415
R1813 a_33552_2420.n34 a_33552_2420.t53 13.4447
R1814 a_33552_2420.n34 a_33552_2420.n33 10.5449
R1815 a_33552_2420.n33 a_33552_2420.t32 15.8415
R1816 a_33552_2420.n33 a_33552_2420.t52 13.4447
R1817 a_33552_2420.n33 a_33552_2420.n32 10.5449
R1818 a_33552_2420.n32 a_33552_2420.t31 15.8415
R1819 a_33552_2420.n32 a_33552_2420.t51 13.4447
R1820 a_33552_2420.n32 a_33552_2420.n31 10.5449
R1821 a_33552_2420.n31 a_33552_2420.t30 15.8415
R1822 a_33552_2420.n31 a_33552_2420.t50 13.4447
R1823 a_33552_2420.n31 a_33552_2420.n30 10.5449
R1824 a_33552_2420.n30 a_33552_2420.t29 15.8415
R1825 a_33552_2420.n30 a_33552_2420.t49 13.4447
R1826 a_33552_2420.n30 a_33552_2420.n29 10.5449
R1827 a_33552_2420.n29 a_33552_2420.t28 15.8415
R1828 a_33552_2420.n29 a_33552_2420.t48 13.4447
R1829 a_33552_2420.n29 a_33552_2420.n28 10.5449
R1830 a_33552_2420.n28 a_33552_2420.t27 15.8415
R1831 a_33552_2420.n28 a_33552_2420.t47 13.4447
R1832 a_33552_2420.n28 a_33552_2420.n27 10.5449
R1833 a_33552_2420.n27 a_33552_2420.t26 15.8415
R1834 a_33552_2420.n27 a_33552_2420.t46 13.4447
R1835 a_33552_2420.n27 a_33552_2420.n26 10.5449
R1836 a_33552_2420.n26 a_33552_2420.t25 15.8415
R1837 a_33552_2420.n26 a_33552_2420.t45 13.4447
R1838 a_33552_2420.n26 a_33552_2420.n25 10.5449
R1839 a_33552_2420.n25 a_33552_2420.t24 15.8415
R1840 a_33552_2420.n25 a_33552_2420.t44 13.4447
R1841 a_33552_2420.n25 a_33552_2420.n24 10.5449
R1842 a_33552_2420.n24 a_33552_2420.t23 15.8415
R1843 a_33552_2420.n24 a_33552_2420.t43 13.4447
R1844 a_33552_2420.n24 a_33552_2420.n23 10.5449
R1845 a_33552_2420.n23 a_33552_2420.t22 15.8415
R1846 a_33552_2420.n23 a_33552_2420.t42 13.4447
R1847 a_33552_2420.n23 a_33552_2420.n22 10.5449
R1848 a_33552_2420.n22 a_33552_2420.t21 15.8415
R1849 a_33552_2420.n22 a_33552_2420.t41 13.4447
R1850 a_33552_2420.n22 a_33552_2420.n21 10.5449
R1851 a_33552_2420.n21 a_33552_2420.t20 16.2795
R1852 a_33552_2420.n21 a_33552_2420.t40 14.7952
R1853 a_33552_2420.n20 a_33552_2420.t36 15.8415
R1854 a_33552_2420.n20 a_33552_2420.t56 13.4447
R1855 a_33552_2420.n20 a_33552_2420.n19 10.5449
R1856 a_33552_2420.n19 a_33552_2420.t37 15.8415
R1857 a_33552_2420.n19 a_33552_2420.t57 13.4447
R1858 a_33552_2420.n19 a_33552_2420.n18 10.5449
R1859 a_33552_2420.n18 a_33552_2420.t38 15.8415
R1860 a_33552_2420.n18 a_33552_2420.t58 13.4447
R1861 a_33552_2420.n18 a_33552_2420.n17 10.5449
R1862 a_33552_2420.n17 a_33552_2420.t39 15.8415
R1863 a_33552_2420.n17 a_33552_2420.t59 13.4447
R1864 a_33552_2420.n12 a_33552_2420.n14 0.877022
R1865 a_33552_2420.n10 a_33552_2420.n12 0.877022
R1866 a_33552_2420.n16 a_33552_2420.n10 0.792891
R1867 a_33552_2420.n14 a_33552_2420.n15 7.31202
R1868 a_33552_2420.n15 a_33552_2420.t10 1.99806
R1869 a_33552_2420.n15 a_33552_2420.t11 1.99806
R1870 a_33552_2420.n14 a_33552_2420.n13 6.4355
R1871 a_33552_2420.n13 a_33552_2420.t12 1.99806
R1872 a_33552_2420.n13 a_33552_2420.t13 1.99806
R1873 a_33552_2420.n12 a_33552_2420.n11 6.4355
R1874 a_33552_2420.n11 a_33552_2420.t14 1.99806
R1875 a_33552_2420.n11 a_33552_2420.t15 1.99806
R1876 a_33552_2420.n10 a_33552_2420.n9 6.4355
R1877 a_33552_2420.n9 a_33552_2420.t16 1.99806
R1878 a_33552_2420.n9 a_33552_2420.t17 1.99806
R1879 a_33552_2420.n5 a_33552_2420.n3 0.877022
R1880 a_33552_2420.n7 a_33552_2420.n5 0.877022
R1881 a_33552_2420.n8 a_33552_2420.n7 0.832022
R1882 a_33552_2420.n7 a_33552_2420.n6 2.68463
R1883 a_33552_2420.n6 a_33552_2420.t6 1.4923
R1884 a_33552_2420.n6 a_33552_2420.t7 2.06607
R1885 a_33552_2420.n5 a_33552_2420.n4 2.68463
R1886 a_33552_2420.n4 a_33552_2420.t4 1.4923
R1887 a_33552_2420.n4 a_33552_2420.t5 2.06607
R1888 a_33552_2420.n3 a_33552_2420.n2 2.68463
R1889 a_33552_2420.n2 a_33552_2420.t2 1.4923
R1890 a_33552_2420.n2 a_33552_2420.t3 2.06607
R1891 a_33552_2420.n3 a_33552_2420.n1 3.52202
R1892 a_33552_2420.n1 a_33552_2420.t0 2.06607
R1893 a_33552_2420.n1 a_33552_2420.t1 1.4923
R1894 a_33552_3608.n0 a_33552_3608.t8 1.4923
R1895 a_33552_3608.t9 a_33552_3608.n0 2.06607
R1896 a_33552_3608.n37 a_33552_3608.n8 0.109291
R1897 a_33552_3608.n16 a_33552_3608.n37 0.156764
R1898 a_33552_3608.n0 a_33552_3608.n16 2.66577
R1899 a_33552_3608.n8 a_33552_3608.n38 6.41071
R1900 a_33552_3608.n38 a_33552_3608.t18 1.99806
R1901 a_33552_3608.n38 a_33552_3608.t19 1.99806
R1902 a_33552_3608.n37 a_33552_3608.n36 2.7371
R1903 a_33552_3608.n36 a_33552_3608.t35 13.4447
R1904 a_33552_3608.n36 a_33552_3608.t55 15.8415
R1905 a_33552_3608.n36 a_33552_3608.n20 10.5449
R1906 a_33552_3608.n36 a_33552_3608.n35 10.5449
R1907 a_33552_3608.n35 a_33552_3608.t34 13.4447
R1908 a_33552_3608.n35 a_33552_3608.t54 15.8415
R1909 a_33552_3608.n35 a_33552_3608.n34 10.5449
R1910 a_33552_3608.n34 a_33552_3608.t33 13.4447
R1911 a_33552_3608.n34 a_33552_3608.t53 15.8415
R1912 a_33552_3608.n34 a_33552_3608.n33 10.5449
R1913 a_33552_3608.n33 a_33552_3608.t32 13.4447
R1914 a_33552_3608.n33 a_33552_3608.t52 15.8415
R1915 a_33552_3608.n33 a_33552_3608.n32 10.5449
R1916 a_33552_3608.n32 a_33552_3608.t31 13.4447
R1917 a_33552_3608.n32 a_33552_3608.t51 15.8415
R1918 a_33552_3608.n32 a_33552_3608.n31 10.5449
R1919 a_33552_3608.n31 a_33552_3608.t30 13.4447
R1920 a_33552_3608.n31 a_33552_3608.t50 15.8415
R1921 a_33552_3608.n31 a_33552_3608.n30 10.5449
R1922 a_33552_3608.n30 a_33552_3608.t29 13.4447
R1923 a_33552_3608.n30 a_33552_3608.t49 15.8415
R1924 a_33552_3608.n30 a_33552_3608.n29 10.5449
R1925 a_33552_3608.n29 a_33552_3608.t28 13.4447
R1926 a_33552_3608.n29 a_33552_3608.t48 15.8415
R1927 a_33552_3608.n29 a_33552_3608.n28 10.5449
R1928 a_33552_3608.n28 a_33552_3608.t27 13.4447
R1929 a_33552_3608.n28 a_33552_3608.t47 15.8415
R1930 a_33552_3608.n28 a_33552_3608.n27 10.5449
R1931 a_33552_3608.n27 a_33552_3608.t26 13.4447
R1932 a_33552_3608.n27 a_33552_3608.t46 15.8415
R1933 a_33552_3608.n27 a_33552_3608.n26 10.5449
R1934 a_33552_3608.n26 a_33552_3608.t25 13.4447
R1935 a_33552_3608.n26 a_33552_3608.t45 15.8415
R1936 a_33552_3608.n26 a_33552_3608.n25 10.5449
R1937 a_33552_3608.n25 a_33552_3608.t24 13.4447
R1938 a_33552_3608.n25 a_33552_3608.t44 15.8415
R1939 a_33552_3608.n25 a_33552_3608.n24 10.5449
R1940 a_33552_3608.n24 a_33552_3608.t23 13.4447
R1941 a_33552_3608.n24 a_33552_3608.t43 15.8415
R1942 a_33552_3608.n24 a_33552_3608.n23 10.5449
R1943 a_33552_3608.n23 a_33552_3608.t22 13.4447
R1944 a_33552_3608.n23 a_33552_3608.t42 15.8415
R1945 a_33552_3608.n23 a_33552_3608.n22 10.5449
R1946 a_33552_3608.n22 a_33552_3608.t21 13.4447
R1947 a_33552_3608.n22 a_33552_3608.t41 15.8415
R1948 a_33552_3608.n22 a_33552_3608.n21 10.5449
R1949 a_33552_3608.n21 a_33552_3608.t20 14.7952
R1950 a_33552_3608.n21 a_33552_3608.t40 16.2795
R1951 a_33552_3608.n20 a_33552_3608.t36 13.4447
R1952 a_33552_3608.n20 a_33552_3608.t56 15.8415
R1953 a_33552_3608.n20 a_33552_3608.n19 10.5449
R1954 a_33552_3608.n19 a_33552_3608.t37 13.4447
R1955 a_33552_3608.n19 a_33552_3608.t57 15.8415
R1956 a_33552_3608.n19 a_33552_3608.n18 10.5449
R1957 a_33552_3608.n18 a_33552_3608.t38 13.4447
R1958 a_33552_3608.n18 a_33552_3608.t58 15.8415
R1959 a_33552_3608.n18 a_33552_3608.n17 10.5449
R1960 a_33552_3608.n17 a_33552_3608.t39 13.4447
R1961 a_33552_3608.n17 a_33552_3608.t59 15.8415
R1962 a_33552_3608.n12 a_33552_3608.n14 0.877022
R1963 a_33552_3608.n10 a_33552_3608.n12 0.877022
R1964 a_33552_3608.n16 a_33552_3608.n10 0.832022
R1965 a_33552_3608.n14 a_33552_3608.n15 3.52202
R1966 a_33552_3608.n15 a_33552_3608.t0 2.06607
R1967 a_33552_3608.n15 a_33552_3608.t1 1.4923
R1968 a_33552_3608.n14 a_33552_3608.n13 2.68463
R1969 a_33552_3608.n13 a_33552_3608.t2 1.4923
R1970 a_33552_3608.n13 a_33552_3608.t3 2.06607
R1971 a_33552_3608.n12 a_33552_3608.n11 2.68463
R1972 a_33552_3608.n11 a_33552_3608.t4 1.4923
R1973 a_33552_3608.n11 a_33552_3608.t5 2.06607
R1974 a_33552_3608.n10 a_33552_3608.n9 2.68463
R1975 a_33552_3608.n9 a_33552_3608.t6 1.4923
R1976 a_33552_3608.n9 a_33552_3608.t7 2.06607
R1977 a_33552_3608.n5 a_33552_3608.n3 0.877022
R1978 a_33552_3608.n7 a_33552_3608.n5 0.877022
R1979 a_33552_3608.n8 a_33552_3608.n7 0.792891
R1980 a_33552_3608.n7 a_33552_3608.n6 6.4355
R1981 a_33552_3608.n6 a_33552_3608.t16 1.99806
R1982 a_33552_3608.n6 a_33552_3608.t17 1.99806
R1983 a_33552_3608.n5 a_33552_3608.n4 6.4355
R1984 a_33552_3608.n4 a_33552_3608.t14 1.99806
R1985 a_33552_3608.n4 a_33552_3608.t15 1.99806
R1986 a_33552_3608.n3 a_33552_3608.n2 6.4355
R1987 a_33552_3608.n2 a_33552_3608.t12 1.99806
R1988 a_33552_3608.n2 a_33552_3608.t13 1.99806
R1989 a_33552_3608.n3 a_33552_3608.n1 7.31202
R1990 a_33552_3608.n1 a_33552_3608.t10 1.99806
R1991 a_33552_3608.n1 a_33552_3608.t11 1.99806
R1992 a_33552_3988.n0 a_33552_3988.t8 1.4923
R1993 a_33552_3988.t9 a_33552_3988.n0 2.06607
R1994 a_33552_3988.n0 a_33552_3988.n8 2.66577
R1995 a_33552_3988.n8 a_33552_3988.n37 0.156764
R1996 a_33552_3988.n37 a_33552_3988.n16 0.109291
R1997 a_33552_3988.n16 a_33552_3988.n38 6.41071
R1998 a_33552_3988.n38 a_33552_3988.t18 1.99806
R1999 a_33552_3988.n38 a_33552_3988.t19 1.99806
R2000 a_33552_3988.n37 a_33552_3988.n36 2.7371
R2001 a_33552_3988.n36 a_33552_3988.t35 15.8415
R2002 a_33552_3988.n36 a_33552_3988.t55 13.4447
R2003 a_33552_3988.n36 a_33552_3988.n20 10.5449
R2004 a_33552_3988.n36 a_33552_3988.n35 10.5449
R2005 a_33552_3988.n35 a_33552_3988.t34 15.8415
R2006 a_33552_3988.n35 a_33552_3988.t54 13.4447
R2007 a_33552_3988.n35 a_33552_3988.n34 10.5449
R2008 a_33552_3988.n34 a_33552_3988.t33 15.8415
R2009 a_33552_3988.n34 a_33552_3988.t53 13.4447
R2010 a_33552_3988.n34 a_33552_3988.n33 10.5449
R2011 a_33552_3988.n33 a_33552_3988.t32 15.8415
R2012 a_33552_3988.n33 a_33552_3988.t52 13.4447
R2013 a_33552_3988.n33 a_33552_3988.n32 10.5449
R2014 a_33552_3988.n32 a_33552_3988.t31 15.8415
R2015 a_33552_3988.n32 a_33552_3988.t51 13.4447
R2016 a_33552_3988.n32 a_33552_3988.n31 10.5449
R2017 a_33552_3988.n31 a_33552_3988.t30 15.8415
R2018 a_33552_3988.n31 a_33552_3988.t50 13.4447
R2019 a_33552_3988.n31 a_33552_3988.n30 10.5449
R2020 a_33552_3988.n30 a_33552_3988.t29 15.8415
R2021 a_33552_3988.n30 a_33552_3988.t49 13.4447
R2022 a_33552_3988.n30 a_33552_3988.n29 10.5449
R2023 a_33552_3988.n29 a_33552_3988.t28 15.8415
R2024 a_33552_3988.n29 a_33552_3988.t48 13.4447
R2025 a_33552_3988.n29 a_33552_3988.n28 10.5449
R2026 a_33552_3988.n28 a_33552_3988.t27 15.8415
R2027 a_33552_3988.n28 a_33552_3988.t47 13.4447
R2028 a_33552_3988.n28 a_33552_3988.n27 10.5449
R2029 a_33552_3988.n27 a_33552_3988.t26 15.8415
R2030 a_33552_3988.n27 a_33552_3988.t46 13.4447
R2031 a_33552_3988.n27 a_33552_3988.n26 10.5449
R2032 a_33552_3988.n26 a_33552_3988.t25 15.8415
R2033 a_33552_3988.n26 a_33552_3988.t45 13.4447
R2034 a_33552_3988.n26 a_33552_3988.n25 10.5449
R2035 a_33552_3988.n25 a_33552_3988.t24 15.8415
R2036 a_33552_3988.n25 a_33552_3988.t44 13.4447
R2037 a_33552_3988.n25 a_33552_3988.n24 10.5449
R2038 a_33552_3988.n24 a_33552_3988.t23 15.8415
R2039 a_33552_3988.n24 a_33552_3988.t43 13.4447
R2040 a_33552_3988.n24 a_33552_3988.n23 10.5449
R2041 a_33552_3988.n23 a_33552_3988.t22 15.8415
R2042 a_33552_3988.n23 a_33552_3988.t42 13.4447
R2043 a_33552_3988.n23 a_33552_3988.n22 10.5449
R2044 a_33552_3988.n22 a_33552_3988.t21 15.8415
R2045 a_33552_3988.n22 a_33552_3988.t41 13.4447
R2046 a_33552_3988.n22 a_33552_3988.n21 10.5449
R2047 a_33552_3988.n21 a_33552_3988.t20 16.2795
R2048 a_33552_3988.n21 a_33552_3988.t40 14.7952
R2049 a_33552_3988.n20 a_33552_3988.t36 15.8415
R2050 a_33552_3988.n20 a_33552_3988.t56 13.4447
R2051 a_33552_3988.n20 a_33552_3988.n19 10.5449
R2052 a_33552_3988.n19 a_33552_3988.t37 15.8415
R2053 a_33552_3988.n19 a_33552_3988.t57 13.4447
R2054 a_33552_3988.n19 a_33552_3988.n18 10.5449
R2055 a_33552_3988.n18 a_33552_3988.t38 15.8415
R2056 a_33552_3988.n18 a_33552_3988.t58 13.4447
R2057 a_33552_3988.n18 a_33552_3988.n17 10.5449
R2058 a_33552_3988.n17 a_33552_3988.t39 15.8415
R2059 a_33552_3988.n17 a_33552_3988.t59 13.4447
R2060 a_33552_3988.n12 a_33552_3988.n14 0.877022
R2061 a_33552_3988.n10 a_33552_3988.n12 0.877022
R2062 a_33552_3988.n16 a_33552_3988.n10 0.792891
R2063 a_33552_3988.n14 a_33552_3988.n15 7.31202
R2064 a_33552_3988.n15 a_33552_3988.t10 1.99806
R2065 a_33552_3988.n15 a_33552_3988.t11 1.99806
R2066 a_33552_3988.n14 a_33552_3988.n13 6.4355
R2067 a_33552_3988.n13 a_33552_3988.t12 1.99806
R2068 a_33552_3988.n13 a_33552_3988.t13 1.99806
R2069 a_33552_3988.n12 a_33552_3988.n11 6.4355
R2070 a_33552_3988.n11 a_33552_3988.t14 1.99806
R2071 a_33552_3988.n11 a_33552_3988.t15 1.99806
R2072 a_33552_3988.n10 a_33552_3988.n9 6.4355
R2073 a_33552_3988.n9 a_33552_3988.t16 1.99806
R2074 a_33552_3988.n9 a_33552_3988.t17 1.99806
R2075 a_33552_3988.n5 a_33552_3988.n3 0.877022
R2076 a_33552_3988.n7 a_33552_3988.n5 0.877022
R2077 a_33552_3988.n8 a_33552_3988.n7 0.832022
R2078 a_33552_3988.n7 a_33552_3988.n6 2.68463
R2079 a_33552_3988.n6 a_33552_3988.t6 1.4923
R2080 a_33552_3988.n6 a_33552_3988.t7 2.06607
R2081 a_33552_3988.n5 a_33552_3988.n4 2.68463
R2082 a_33552_3988.n4 a_33552_3988.t4 1.4923
R2083 a_33552_3988.n4 a_33552_3988.t5 2.06607
R2084 a_33552_3988.n3 a_33552_3988.n2 2.68463
R2085 a_33552_3988.n2 a_33552_3988.t2 1.4923
R2086 a_33552_3988.n2 a_33552_3988.t3 2.06607
R2087 a_33552_3988.n3 a_33552_3988.n1 3.52202
R2088 a_33552_3988.n1 a_33552_3988.t0 2.06607
R2089 a_33552_3988.n1 a_33552_3988.t1 1.4923
R2090 a_33552_5176.n0 a_33552_5176.t8 1.4923
R2091 a_33552_5176.t9 a_33552_5176.n0 2.06607
R2092 a_33552_5176.n37 a_33552_5176.n8 0.109291
R2093 a_33552_5176.n16 a_33552_5176.n37 0.156764
R2094 a_33552_5176.n0 a_33552_5176.n16 2.66577
R2095 a_33552_5176.n8 a_33552_5176.n38 6.41071
R2096 a_33552_5176.n38 a_33552_5176.t18 1.99806
R2097 a_33552_5176.n38 a_33552_5176.t19 1.99806
R2098 a_33552_5176.n37 a_33552_5176.n36 2.7371
R2099 a_33552_5176.n36 a_33552_5176.t35 13.4447
R2100 a_33552_5176.n36 a_33552_5176.t55 15.8415
R2101 a_33552_5176.n36 a_33552_5176.n20 10.5449
R2102 a_33552_5176.n36 a_33552_5176.n35 10.5449
R2103 a_33552_5176.n35 a_33552_5176.t34 13.4447
R2104 a_33552_5176.n35 a_33552_5176.t54 15.8415
R2105 a_33552_5176.n35 a_33552_5176.n34 10.5449
R2106 a_33552_5176.n34 a_33552_5176.t33 13.4447
R2107 a_33552_5176.n34 a_33552_5176.t53 15.8415
R2108 a_33552_5176.n34 a_33552_5176.n33 10.5449
R2109 a_33552_5176.n33 a_33552_5176.t32 13.4447
R2110 a_33552_5176.n33 a_33552_5176.t52 15.8415
R2111 a_33552_5176.n33 a_33552_5176.n32 10.5449
R2112 a_33552_5176.n32 a_33552_5176.t31 13.4447
R2113 a_33552_5176.n32 a_33552_5176.t51 15.8415
R2114 a_33552_5176.n32 a_33552_5176.n31 10.5449
R2115 a_33552_5176.n31 a_33552_5176.t30 13.4447
R2116 a_33552_5176.n31 a_33552_5176.t50 15.8415
R2117 a_33552_5176.n31 a_33552_5176.n30 10.5449
R2118 a_33552_5176.n30 a_33552_5176.t29 13.4447
R2119 a_33552_5176.n30 a_33552_5176.t49 15.8415
R2120 a_33552_5176.n30 a_33552_5176.n29 10.5449
R2121 a_33552_5176.n29 a_33552_5176.t28 13.4447
R2122 a_33552_5176.n29 a_33552_5176.t48 15.8415
R2123 a_33552_5176.n29 a_33552_5176.n28 10.5449
R2124 a_33552_5176.n28 a_33552_5176.t27 13.4447
R2125 a_33552_5176.n28 a_33552_5176.t47 15.8415
R2126 a_33552_5176.n28 a_33552_5176.n27 10.5449
R2127 a_33552_5176.n27 a_33552_5176.t26 13.4447
R2128 a_33552_5176.n27 a_33552_5176.t46 15.8415
R2129 a_33552_5176.n27 a_33552_5176.n26 10.5449
R2130 a_33552_5176.n26 a_33552_5176.t25 13.4447
R2131 a_33552_5176.n26 a_33552_5176.t45 15.8415
R2132 a_33552_5176.n26 a_33552_5176.n25 10.5449
R2133 a_33552_5176.n25 a_33552_5176.t24 13.4447
R2134 a_33552_5176.n25 a_33552_5176.t44 15.8415
R2135 a_33552_5176.n25 a_33552_5176.n24 10.5449
R2136 a_33552_5176.n24 a_33552_5176.t23 13.4447
R2137 a_33552_5176.n24 a_33552_5176.t43 15.8415
R2138 a_33552_5176.n24 a_33552_5176.n23 10.5449
R2139 a_33552_5176.n23 a_33552_5176.t22 13.4447
R2140 a_33552_5176.n23 a_33552_5176.t42 15.8415
R2141 a_33552_5176.n23 a_33552_5176.n22 10.5449
R2142 a_33552_5176.n22 a_33552_5176.t21 13.4447
R2143 a_33552_5176.n22 a_33552_5176.t41 15.8415
R2144 a_33552_5176.n22 a_33552_5176.n21 10.5449
R2145 a_33552_5176.n21 a_33552_5176.t20 14.7952
R2146 a_33552_5176.n21 a_33552_5176.t40 16.2795
R2147 a_33552_5176.n20 a_33552_5176.t36 13.4447
R2148 a_33552_5176.n20 a_33552_5176.t56 15.8415
R2149 a_33552_5176.n20 a_33552_5176.n19 10.5449
R2150 a_33552_5176.n19 a_33552_5176.t37 13.4447
R2151 a_33552_5176.n19 a_33552_5176.t57 15.8415
R2152 a_33552_5176.n19 a_33552_5176.n18 10.5449
R2153 a_33552_5176.n18 a_33552_5176.t38 13.4447
R2154 a_33552_5176.n18 a_33552_5176.t58 15.8415
R2155 a_33552_5176.n18 a_33552_5176.n17 10.5449
R2156 a_33552_5176.n17 a_33552_5176.t39 13.4447
R2157 a_33552_5176.n17 a_33552_5176.t59 15.8415
R2158 a_33552_5176.n12 a_33552_5176.n14 0.877022
R2159 a_33552_5176.n10 a_33552_5176.n12 0.877022
R2160 a_33552_5176.n16 a_33552_5176.n10 0.832022
R2161 a_33552_5176.n14 a_33552_5176.n15 3.52202
R2162 a_33552_5176.n15 a_33552_5176.t0 2.06607
R2163 a_33552_5176.n15 a_33552_5176.t1 1.4923
R2164 a_33552_5176.n14 a_33552_5176.n13 2.68463
R2165 a_33552_5176.n13 a_33552_5176.t2 1.4923
R2166 a_33552_5176.n13 a_33552_5176.t3 2.06607
R2167 a_33552_5176.n12 a_33552_5176.n11 2.68463
R2168 a_33552_5176.n11 a_33552_5176.t4 1.4923
R2169 a_33552_5176.n11 a_33552_5176.t5 2.06607
R2170 a_33552_5176.n10 a_33552_5176.n9 2.68463
R2171 a_33552_5176.n9 a_33552_5176.t6 1.4923
R2172 a_33552_5176.n9 a_33552_5176.t7 2.06607
R2173 a_33552_5176.n5 a_33552_5176.n3 0.877022
R2174 a_33552_5176.n7 a_33552_5176.n5 0.877022
R2175 a_33552_5176.n8 a_33552_5176.n7 0.792891
R2176 a_33552_5176.n7 a_33552_5176.n6 6.4355
R2177 a_33552_5176.n6 a_33552_5176.t16 1.99806
R2178 a_33552_5176.n6 a_33552_5176.t17 1.99806
R2179 a_33552_5176.n5 a_33552_5176.n4 6.4355
R2180 a_33552_5176.n4 a_33552_5176.t14 1.99806
R2181 a_33552_5176.n4 a_33552_5176.t15 1.99806
R2182 a_33552_5176.n3 a_33552_5176.n2 6.4355
R2183 a_33552_5176.n2 a_33552_5176.t12 1.99806
R2184 a_33552_5176.n2 a_33552_5176.t13 1.99806
R2185 a_33552_5176.n3 a_33552_5176.n1 7.31202
R2186 a_33552_5176.n1 a_33552_5176.t10 1.99806
R2187 a_33552_5176.n1 a_33552_5176.t11 1.99806
R2188 a_33552_5556.n0 a_33552_5556.t8 1.4923
R2189 a_33552_5556.t9 a_33552_5556.n0 2.06607
R2190 a_33552_5556.n0 a_33552_5556.n8 2.66577
R2191 a_33552_5556.n8 a_33552_5556.n37 0.156764
R2192 a_33552_5556.n37 a_33552_5556.n16 0.109291
R2193 a_33552_5556.n16 a_33552_5556.n38 6.41071
R2194 a_33552_5556.n38 a_33552_5556.t18 1.99806
R2195 a_33552_5556.n38 a_33552_5556.t19 1.99806
R2196 a_33552_5556.n37 a_33552_5556.n36 2.7371
R2197 a_33552_5556.n36 a_33552_5556.t35 15.8415
R2198 a_33552_5556.n36 a_33552_5556.t55 13.4447
R2199 a_33552_5556.n36 a_33552_5556.n20 10.5449
R2200 a_33552_5556.n36 a_33552_5556.n35 10.5449
R2201 a_33552_5556.n35 a_33552_5556.t34 15.8415
R2202 a_33552_5556.n35 a_33552_5556.t54 13.4447
R2203 a_33552_5556.n35 a_33552_5556.n34 10.5449
R2204 a_33552_5556.n34 a_33552_5556.t33 15.8415
R2205 a_33552_5556.n34 a_33552_5556.t53 13.4447
R2206 a_33552_5556.n34 a_33552_5556.n33 10.5449
R2207 a_33552_5556.n33 a_33552_5556.t32 15.8415
R2208 a_33552_5556.n33 a_33552_5556.t52 13.4447
R2209 a_33552_5556.n33 a_33552_5556.n32 10.5449
R2210 a_33552_5556.n32 a_33552_5556.t31 15.8415
R2211 a_33552_5556.n32 a_33552_5556.t51 13.4447
R2212 a_33552_5556.n32 a_33552_5556.n31 10.5449
R2213 a_33552_5556.n31 a_33552_5556.t30 15.8415
R2214 a_33552_5556.n31 a_33552_5556.t50 13.4447
R2215 a_33552_5556.n31 a_33552_5556.n30 10.5449
R2216 a_33552_5556.n30 a_33552_5556.t29 15.8415
R2217 a_33552_5556.n30 a_33552_5556.t49 13.4447
R2218 a_33552_5556.n30 a_33552_5556.n29 10.5449
R2219 a_33552_5556.n29 a_33552_5556.t28 15.8415
R2220 a_33552_5556.n29 a_33552_5556.t48 13.4447
R2221 a_33552_5556.n29 a_33552_5556.n28 10.5449
R2222 a_33552_5556.n28 a_33552_5556.t27 15.8415
R2223 a_33552_5556.n28 a_33552_5556.t47 13.4447
R2224 a_33552_5556.n28 a_33552_5556.n27 10.5449
R2225 a_33552_5556.n27 a_33552_5556.t26 15.8415
R2226 a_33552_5556.n27 a_33552_5556.t46 13.4447
R2227 a_33552_5556.n27 a_33552_5556.n26 10.5449
R2228 a_33552_5556.n26 a_33552_5556.t25 15.8415
R2229 a_33552_5556.n26 a_33552_5556.t45 13.4447
R2230 a_33552_5556.n26 a_33552_5556.n25 10.5449
R2231 a_33552_5556.n25 a_33552_5556.t24 15.8415
R2232 a_33552_5556.n25 a_33552_5556.t44 13.4447
R2233 a_33552_5556.n25 a_33552_5556.n24 10.5449
R2234 a_33552_5556.n24 a_33552_5556.t23 15.8415
R2235 a_33552_5556.n24 a_33552_5556.t43 13.4447
R2236 a_33552_5556.n24 a_33552_5556.n23 10.5449
R2237 a_33552_5556.n23 a_33552_5556.t22 15.8415
R2238 a_33552_5556.n23 a_33552_5556.t42 13.4447
R2239 a_33552_5556.n23 a_33552_5556.n22 10.5449
R2240 a_33552_5556.n22 a_33552_5556.t21 15.8415
R2241 a_33552_5556.n22 a_33552_5556.t41 13.4447
R2242 a_33552_5556.n22 a_33552_5556.n21 10.5449
R2243 a_33552_5556.n21 a_33552_5556.t20 16.2795
R2244 a_33552_5556.n21 a_33552_5556.t40 14.7952
R2245 a_33552_5556.n20 a_33552_5556.t36 15.8415
R2246 a_33552_5556.n20 a_33552_5556.t56 13.4447
R2247 a_33552_5556.n20 a_33552_5556.n19 10.5449
R2248 a_33552_5556.n19 a_33552_5556.t37 15.8415
R2249 a_33552_5556.n19 a_33552_5556.t57 13.4447
R2250 a_33552_5556.n19 a_33552_5556.n18 10.5449
R2251 a_33552_5556.n18 a_33552_5556.t38 15.8415
R2252 a_33552_5556.n18 a_33552_5556.t58 13.4447
R2253 a_33552_5556.n18 a_33552_5556.n17 10.5449
R2254 a_33552_5556.n17 a_33552_5556.t39 15.8415
R2255 a_33552_5556.n17 a_33552_5556.t59 13.4447
R2256 a_33552_5556.n12 a_33552_5556.n14 0.877022
R2257 a_33552_5556.n10 a_33552_5556.n12 0.877022
R2258 a_33552_5556.n16 a_33552_5556.n10 0.792891
R2259 a_33552_5556.n14 a_33552_5556.n15 7.31202
R2260 a_33552_5556.n15 a_33552_5556.t10 1.99806
R2261 a_33552_5556.n15 a_33552_5556.t11 1.99806
R2262 a_33552_5556.n14 a_33552_5556.n13 6.4355
R2263 a_33552_5556.n13 a_33552_5556.t12 1.99806
R2264 a_33552_5556.n13 a_33552_5556.t13 1.99806
R2265 a_33552_5556.n12 a_33552_5556.n11 6.4355
R2266 a_33552_5556.n11 a_33552_5556.t14 1.99806
R2267 a_33552_5556.n11 a_33552_5556.t15 1.99806
R2268 a_33552_5556.n10 a_33552_5556.n9 6.4355
R2269 a_33552_5556.n9 a_33552_5556.t16 1.99806
R2270 a_33552_5556.n9 a_33552_5556.t17 1.99806
R2271 a_33552_5556.n5 a_33552_5556.n3 0.877022
R2272 a_33552_5556.n7 a_33552_5556.n5 0.877022
R2273 a_33552_5556.n8 a_33552_5556.n7 0.832022
R2274 a_33552_5556.n7 a_33552_5556.n6 2.68463
R2275 a_33552_5556.n6 a_33552_5556.t6 1.4923
R2276 a_33552_5556.n6 a_33552_5556.t7 2.06607
R2277 a_33552_5556.n5 a_33552_5556.n4 2.68463
R2278 a_33552_5556.n4 a_33552_5556.t4 1.4923
R2279 a_33552_5556.n4 a_33552_5556.t5 2.06607
R2280 a_33552_5556.n3 a_33552_5556.n2 2.68463
R2281 a_33552_5556.n2 a_33552_5556.t2 1.4923
R2282 a_33552_5556.n2 a_33552_5556.t3 2.06607
R2283 a_33552_5556.n3 a_33552_5556.n1 3.52202
R2284 a_33552_5556.n1 a_33552_5556.t0 2.06607
R2285 a_33552_5556.n1 a_33552_5556.t1 1.4923
R2286 a_n132_9672.n0 a_n132_9672.t19 1.4923
R2287 a_n132_9672.t20 a_n132_9672.n0 2.06607
R2288 a_n132_9672.n2 a_n132_9672.n1 2.6005
R2289 a_n132_9672.n4 a_n132_9672.n3 2.6005
R2290 a_n132_9672.n6 a_n132_9672.n5 2.6005
R2291 a_n132_9672.n8 a_n132_9672.n7 2.6005
R2292 a_n132_9672.n2 a_n132_9672.n18 0.080637
R2293 a_n132_9672.n4 a_n132_9672.n2 0.276664
R2294 a_n132_9672.n6 a_n132_9672.n4 0.276664
R2295 a_n132_9672.n8 a_n132_9672.n6 0.276664
R2296 a_n132_9672.n0 a_n132_9672.n8 2.87666
R2297 a_n132_9672.n37 a_n132_9672.t0 75.6154
R2298 a_n132_9672.n18 a_n132_9672.n37 0.1455
R2299 a_n132_9672.n37 a_n132_9672.n20 0.105151
R2300 a_n132_9672.n20 a_n132_9672.n22 0.313058
R2301 a_n132_9672.n22 a_n132_9672.n24 0.313058
R2302 a_n132_9672.n24 a_n132_9672.n26 0.313058
R2303 a_n132_9672.n32 a_n132_9672.n30 0.313058
R2304 a_n132_9672.n34 a_n132_9672.n32 0.313058
R2305 a_n132_9672.n36 a_n132_9672.n34 0.313058
R2306 a_n132_9672.n37 a_n132_9672.n36 0.0828256
R2307 a_n132_9672.n36 a_n132_9672.n35 6.30833
R2308 a_n132_9672.n35 a_n132_9672.t29 1.99806
R2309 a_n132_9672.n35 a_n132_9672.t30 1.99806
R2310 a_n132_9672.n34 a_n132_9672.n33 6.30833
R2311 a_n132_9672.n33 a_n132_9672.t27 1.99806
R2312 a_n132_9672.n33 a_n132_9672.t28 1.99806
R2313 a_n132_9672.n32 a_n132_9672.n31 6.30833
R2314 a_n132_9672.n31 a_n132_9672.t25 1.99806
R2315 a_n132_9672.n31 a_n132_9672.t26 1.99806
R2316 a_n132_9672.n30 a_n132_9672.n29 6.30833
R2317 a_n132_9672.n29 a_n132_9672.t23 1.99806
R2318 a_n132_9672.n29 a_n132_9672.t24 1.99806
R2319 a_n132_9672.n30 a_n132_9672.n28 6.61789
R2320 a_n132_9672.n28 a_n132_9672.t21 1.99806
R2321 a_n132_9672.n28 a_n132_9672.t22 1.99806
R2322 a_n132_9672.n26 a_n132_9672.n27 6.62088
R2323 a_n132_9672.n27 a_n132_9672.t39 1.99806
R2324 a_n132_9672.n27 a_n132_9672.t40 1.99806
R2325 a_n132_9672.n26 a_n132_9672.n25 6.30833
R2326 a_n132_9672.n25 a_n132_9672.t37 1.99806
R2327 a_n132_9672.n25 a_n132_9672.t38 1.99806
R2328 a_n132_9672.n24 a_n132_9672.n23 6.30833
R2329 a_n132_9672.n23 a_n132_9672.t35 1.99806
R2330 a_n132_9672.n23 a_n132_9672.t36 1.99806
R2331 a_n132_9672.n22 a_n132_9672.n21 6.30833
R2332 a_n132_9672.n21 a_n132_9672.t33 1.99806
R2333 a_n132_9672.n21 a_n132_9672.t34 1.99806
R2334 a_n132_9672.n20 a_n132_9672.n19 6.30833
R2335 a_n132_9672.n19 a_n132_9672.t31 1.99806
R2336 a_n132_9672.n19 a_n132_9672.t32 1.99806
R2337 a_n132_9672.n11 a_n132_9672.n10 2.6005
R2338 a_n132_9672.n13 a_n132_9672.n12 2.6005
R2339 a_n132_9672.n15 a_n132_9672.n14 2.6005
R2340 a_n132_9672.n17 a_n132_9672.n16 2.6005
R2341 a_n132_9672.n11 a_n132_9672.n9 2.86434
R2342 a_n132_9672.n13 a_n132_9672.n11 0.276664
R2343 a_n132_9672.n15 a_n132_9672.n13 0.276664
R2344 a_n132_9672.n17 a_n132_9672.n15 0.276664
R2345 a_n132_9672.n18 a_n132_9672.n17 0.0855685
R2346 a_n132_9672.n16 a_n132_9672.t9 1.4923
R2347 a_n132_9672.n16 a_n132_9672.t10 2.06607
R2348 a_n132_9672.n14 a_n132_9672.t7 1.4923
R2349 a_n132_9672.n14 a_n132_9672.t8 2.06607
R2350 a_n132_9672.n12 a_n132_9672.t5 1.4923
R2351 a_n132_9672.n12 a_n132_9672.t6 2.06607
R2352 a_n132_9672.n10 a_n132_9672.t3 1.4923
R2353 a_n132_9672.n10 a_n132_9672.t4 2.06607
R2354 a_n132_9672.n9 a_n132_9672.t1 2.06607
R2355 a_n132_9672.n9 a_n132_9672.t2 1.4923
R2356 a_n132_9672.n7 a_n132_9672.t17 1.4923
R2357 a_n132_9672.n7 a_n132_9672.t18 2.06607
R2358 a_n132_9672.n5 a_n132_9672.t15 1.4923
R2359 a_n132_9672.n5 a_n132_9672.t16 2.06607
R2360 a_n132_9672.n3 a_n132_9672.t13 1.4923
R2361 a_n132_9672.n3 a_n132_9672.t14 2.06607
R2362 a_n132_9672.n1 a_n132_9672.t11 1.4923
R2363 a_n132_9672.n1 a_n132_9672.t12 2.06607
R2364 a_n132_12072.n0 a_n132_12072.t19 1.4923
R2365 a_n132_12072.t20 a_n132_12072.n0 2.06607
R2366 a_n132_12072.n2 a_n132_12072.n1 2.6005
R2367 a_n132_12072.n4 a_n132_12072.n3 2.6005
R2368 a_n132_12072.n6 a_n132_12072.n5 2.6005
R2369 a_n132_12072.n8 a_n132_12072.n7 2.6005
R2370 a_n132_12072.n2 a_n132_12072.n18 0.080637
R2371 a_n132_12072.n4 a_n132_12072.n2 0.276664
R2372 a_n132_12072.n6 a_n132_12072.n4 0.276664
R2373 a_n132_12072.n8 a_n132_12072.n6 0.276664
R2374 a_n132_12072.n0 a_n132_12072.n8 2.87666
R2375 a_n132_12072.n18 a_n132_12072.n37 0.145
R2376 a_n132_12072.n37 a_n132_12072.t0 77.0469
R2377 a_n132_12072.n37 a_n132_12072.n27 0.105151
R2378 a_n132_12072.n27 a_n132_12072.n25 0.313058
R2379 a_n132_12072.n25 a_n132_12072.n23 0.313058
R2380 a_n132_12072.n23 a_n132_12072.n21 0.313058
R2381 a_n132_12072.n33 a_n132_12072.n35 0.313058
R2382 a_n132_12072.n31 a_n132_12072.n33 0.313058
R2383 a_n132_12072.n29 a_n132_12072.n31 0.313058
R2384 a_n132_12072.n37 a_n132_12072.n29 0.0828256
R2385 a_n132_12072.n35 a_n132_12072.n36 6.61789
R2386 a_n132_12072.n36 a_n132_12072.t21 1.99806
R2387 a_n132_12072.n36 a_n132_12072.t22 1.99806
R2388 a_n132_12072.n35 a_n132_12072.n34 6.30833
R2389 a_n132_12072.n34 a_n132_12072.t23 1.99806
R2390 a_n132_12072.n34 a_n132_12072.t24 1.99806
R2391 a_n132_12072.n33 a_n132_12072.n32 6.30833
R2392 a_n132_12072.n32 a_n132_12072.t25 1.99806
R2393 a_n132_12072.n32 a_n132_12072.t26 1.99806
R2394 a_n132_12072.n31 a_n132_12072.n30 6.30833
R2395 a_n132_12072.n30 a_n132_12072.t27 1.99806
R2396 a_n132_12072.n30 a_n132_12072.t28 1.99806
R2397 a_n132_12072.n29 a_n132_12072.n28 6.30833
R2398 a_n132_12072.n28 a_n132_12072.t29 1.99806
R2399 a_n132_12072.n28 a_n132_12072.t30 1.99806
R2400 a_n132_12072.n27 a_n132_12072.n26 6.30833
R2401 a_n132_12072.n26 a_n132_12072.t31 1.99806
R2402 a_n132_12072.n26 a_n132_12072.t32 1.99806
R2403 a_n132_12072.n25 a_n132_12072.n24 6.30833
R2404 a_n132_12072.n24 a_n132_12072.t33 1.99806
R2405 a_n132_12072.n24 a_n132_12072.t34 1.99806
R2406 a_n132_12072.n23 a_n132_12072.n22 6.30833
R2407 a_n132_12072.n22 a_n132_12072.t35 1.99806
R2408 a_n132_12072.n22 a_n132_12072.t36 1.99806
R2409 a_n132_12072.n21 a_n132_12072.n20 6.30833
R2410 a_n132_12072.n20 a_n132_12072.t37 1.99806
R2411 a_n132_12072.n20 a_n132_12072.t38 1.99806
R2412 a_n132_12072.n21 a_n132_12072.n19 6.62088
R2413 a_n132_12072.n19 a_n132_12072.t39 1.99806
R2414 a_n132_12072.n19 a_n132_12072.t40 1.99806
R2415 a_n132_12072.n11 a_n132_12072.n10 2.6005
R2416 a_n132_12072.n13 a_n132_12072.n12 2.6005
R2417 a_n132_12072.n15 a_n132_12072.n14 2.6005
R2418 a_n132_12072.n17 a_n132_12072.n16 2.6005
R2419 a_n132_12072.n11 a_n132_12072.n9 2.86434
R2420 a_n132_12072.n13 a_n132_12072.n11 0.276664
R2421 a_n132_12072.n15 a_n132_12072.n13 0.276664
R2422 a_n132_12072.n17 a_n132_12072.n15 0.276664
R2423 a_n132_12072.n18 a_n132_12072.n17 0.0855685
R2424 a_n132_12072.n16 a_n132_12072.t9 1.4923
R2425 a_n132_12072.n16 a_n132_12072.t10 2.06607
R2426 a_n132_12072.n14 a_n132_12072.t7 1.4923
R2427 a_n132_12072.n14 a_n132_12072.t8 2.06607
R2428 a_n132_12072.n12 a_n132_12072.t5 1.4923
R2429 a_n132_12072.n12 a_n132_12072.t6 2.06607
R2430 a_n132_12072.n10 a_n132_12072.t3 1.4923
R2431 a_n132_12072.n10 a_n132_12072.t4 2.06607
R2432 a_n132_12072.n9 a_n132_12072.t1 2.06607
R2433 a_n132_12072.n9 a_n132_12072.t2 1.4923
R2434 a_n132_12072.n7 a_n132_12072.t17 1.4923
R2435 a_n132_12072.n7 a_n132_12072.t18 2.06607
R2436 a_n132_12072.n5 a_n132_12072.t15 1.4923
R2437 a_n132_12072.n5 a_n132_12072.t16 2.06607
R2438 a_n132_12072.n3 a_n132_12072.t13 1.4923
R2439 a_n132_12072.n3 a_n132_12072.t14 2.06607
R2440 a_n132_12072.n1 a_n132_12072.t11 1.4923
R2441 a_n132_12072.n1 a_n132_12072.t12 2.06607
R2442 a_n132_14472.n0 a_n132_14472.t19 1.4923
R2443 a_n132_14472.t20 a_n132_14472.n0 2.06607
R2444 a_n132_14472.n2 a_n132_14472.n1 2.6005
R2445 a_n132_14472.n4 a_n132_14472.n3 2.6005
R2446 a_n132_14472.n6 a_n132_14472.n5 2.6005
R2447 a_n132_14472.n8 a_n132_14472.n7 2.6005
R2448 a_n132_14472.n2 a_n132_14472.n18 0.080637
R2449 a_n132_14472.n4 a_n132_14472.n2 0.276664
R2450 a_n132_14472.n6 a_n132_14472.n4 0.276664
R2451 a_n132_14472.n8 a_n132_14472.n6 0.276664
R2452 a_n132_14472.n0 a_n132_14472.n8 2.87666
R2453 a_n132_14472.n37 a_n132_14472.t0 79.2514
R2454 a_n132_14472.n18 a_n132_14472.n37 0.1455
R2455 a_n132_14472.n37 a_n132_14472.n20 0.105151
R2456 a_n132_14472.n20 a_n132_14472.n22 0.313058
R2457 a_n132_14472.n22 a_n132_14472.n24 0.313058
R2458 a_n132_14472.n24 a_n132_14472.n26 0.313058
R2459 a_n132_14472.n32 a_n132_14472.n30 0.313058
R2460 a_n132_14472.n34 a_n132_14472.n32 0.313058
R2461 a_n132_14472.n36 a_n132_14472.n34 0.313058
R2462 a_n132_14472.n37 a_n132_14472.n36 0.0828256
R2463 a_n132_14472.n36 a_n132_14472.n35 6.30833
R2464 a_n132_14472.n35 a_n132_14472.t29 1.99806
R2465 a_n132_14472.n35 a_n132_14472.t30 1.99806
R2466 a_n132_14472.n34 a_n132_14472.n33 6.30833
R2467 a_n132_14472.n33 a_n132_14472.t27 1.99806
R2468 a_n132_14472.n33 a_n132_14472.t28 1.99806
R2469 a_n132_14472.n32 a_n132_14472.n31 6.30833
R2470 a_n132_14472.n31 a_n132_14472.t25 1.99806
R2471 a_n132_14472.n31 a_n132_14472.t26 1.99806
R2472 a_n132_14472.n30 a_n132_14472.n29 6.30833
R2473 a_n132_14472.n29 a_n132_14472.t23 1.99806
R2474 a_n132_14472.n29 a_n132_14472.t24 1.99806
R2475 a_n132_14472.n30 a_n132_14472.n28 6.61789
R2476 a_n132_14472.n28 a_n132_14472.t21 1.99806
R2477 a_n132_14472.n28 a_n132_14472.t22 1.99806
R2478 a_n132_14472.n26 a_n132_14472.n27 6.62088
R2479 a_n132_14472.n27 a_n132_14472.t39 1.99806
R2480 a_n132_14472.n27 a_n132_14472.t40 1.99806
R2481 a_n132_14472.n26 a_n132_14472.n25 6.30833
R2482 a_n132_14472.n25 a_n132_14472.t37 1.99806
R2483 a_n132_14472.n25 a_n132_14472.t38 1.99806
R2484 a_n132_14472.n24 a_n132_14472.n23 6.30833
R2485 a_n132_14472.n23 a_n132_14472.t35 1.99806
R2486 a_n132_14472.n23 a_n132_14472.t36 1.99806
R2487 a_n132_14472.n22 a_n132_14472.n21 6.30833
R2488 a_n132_14472.n21 a_n132_14472.t33 1.99806
R2489 a_n132_14472.n21 a_n132_14472.t34 1.99806
R2490 a_n132_14472.n20 a_n132_14472.n19 6.30833
R2491 a_n132_14472.n19 a_n132_14472.t31 1.99806
R2492 a_n132_14472.n19 a_n132_14472.t32 1.99806
R2493 a_n132_14472.n11 a_n132_14472.n10 2.6005
R2494 a_n132_14472.n13 a_n132_14472.n12 2.6005
R2495 a_n132_14472.n15 a_n132_14472.n14 2.6005
R2496 a_n132_14472.n17 a_n132_14472.n16 2.6005
R2497 a_n132_14472.n11 a_n132_14472.n9 2.86434
R2498 a_n132_14472.n13 a_n132_14472.n11 0.276664
R2499 a_n132_14472.n15 a_n132_14472.n13 0.276664
R2500 a_n132_14472.n17 a_n132_14472.n15 0.276664
R2501 a_n132_14472.n18 a_n132_14472.n17 0.0855685
R2502 a_n132_14472.n16 a_n132_14472.t9 1.4923
R2503 a_n132_14472.n16 a_n132_14472.t10 2.06607
R2504 a_n132_14472.n14 a_n132_14472.t7 1.4923
R2505 a_n132_14472.n14 a_n132_14472.t8 2.06607
R2506 a_n132_14472.n12 a_n132_14472.t5 1.4923
R2507 a_n132_14472.n12 a_n132_14472.t6 2.06607
R2508 a_n132_14472.n10 a_n132_14472.t3 1.4923
R2509 a_n132_14472.n10 a_n132_14472.t4 2.06607
R2510 a_n132_14472.n9 a_n132_14472.t1 2.06607
R2511 a_n132_14472.n9 a_n132_14472.t2 1.4923
R2512 a_n132_14472.n7 a_n132_14472.t17 1.4923
R2513 a_n132_14472.n7 a_n132_14472.t18 2.06607
R2514 a_n132_14472.n5 a_n132_14472.t15 1.4923
R2515 a_n132_14472.n5 a_n132_14472.t16 2.06607
R2516 a_n132_14472.n3 a_n132_14472.t13 1.4923
R2517 a_n132_14472.n3 a_n132_14472.t14 2.06607
R2518 a_n132_14472.n1 a_n132_14472.t11 1.4923
R2519 a_n132_14472.n1 a_n132_14472.t12 2.06607
R2520 a_n132_16872.n0 a_n132_16872.t19 1.4923
R2521 a_n132_16872.t20 a_n132_16872.n0 2.06607
R2522 a_n132_16872.n2 a_n132_16872.n1 2.6005
R2523 a_n132_16872.n4 a_n132_16872.n3 2.6005
R2524 a_n132_16872.n6 a_n132_16872.n5 2.6005
R2525 a_n132_16872.n8 a_n132_16872.n7 2.6005
R2526 a_n132_16872.n2 a_n132_16872.n18 0.080637
R2527 a_n132_16872.n4 a_n132_16872.n2 0.276664
R2528 a_n132_16872.n6 a_n132_16872.n4 0.276664
R2529 a_n132_16872.n8 a_n132_16872.n6 0.276664
R2530 a_n132_16872.n0 a_n132_16872.n8 2.87666
R2531 a_n132_16872.n18 a_n132_16872.n37 0.145
R2532 a_n132_16872.n37 a_n132_16872.t0 80.6829
R2533 a_n132_16872.n37 a_n132_16872.n27 0.105151
R2534 a_n132_16872.n27 a_n132_16872.n25 0.313058
R2535 a_n132_16872.n25 a_n132_16872.n23 0.313058
R2536 a_n132_16872.n23 a_n132_16872.n21 0.313058
R2537 a_n132_16872.n33 a_n132_16872.n35 0.313058
R2538 a_n132_16872.n31 a_n132_16872.n33 0.313058
R2539 a_n132_16872.n29 a_n132_16872.n31 0.313058
R2540 a_n132_16872.n37 a_n132_16872.n29 0.0828256
R2541 a_n132_16872.n35 a_n132_16872.n36 6.61789
R2542 a_n132_16872.n36 a_n132_16872.t21 1.99806
R2543 a_n132_16872.n36 a_n132_16872.t22 1.99806
R2544 a_n132_16872.n35 a_n132_16872.n34 6.30833
R2545 a_n132_16872.n34 a_n132_16872.t23 1.99806
R2546 a_n132_16872.n34 a_n132_16872.t24 1.99806
R2547 a_n132_16872.n33 a_n132_16872.n32 6.30833
R2548 a_n132_16872.n32 a_n132_16872.t25 1.99806
R2549 a_n132_16872.n32 a_n132_16872.t26 1.99806
R2550 a_n132_16872.n31 a_n132_16872.n30 6.30833
R2551 a_n132_16872.n30 a_n132_16872.t27 1.99806
R2552 a_n132_16872.n30 a_n132_16872.t28 1.99806
R2553 a_n132_16872.n29 a_n132_16872.n28 6.30833
R2554 a_n132_16872.n28 a_n132_16872.t29 1.99806
R2555 a_n132_16872.n28 a_n132_16872.t30 1.99806
R2556 a_n132_16872.n27 a_n132_16872.n26 6.30833
R2557 a_n132_16872.n26 a_n132_16872.t31 1.99806
R2558 a_n132_16872.n26 a_n132_16872.t32 1.99806
R2559 a_n132_16872.n25 a_n132_16872.n24 6.30833
R2560 a_n132_16872.n24 a_n132_16872.t33 1.99806
R2561 a_n132_16872.n24 a_n132_16872.t34 1.99806
R2562 a_n132_16872.n23 a_n132_16872.n22 6.30833
R2563 a_n132_16872.n22 a_n132_16872.t35 1.99806
R2564 a_n132_16872.n22 a_n132_16872.t36 1.99806
R2565 a_n132_16872.n21 a_n132_16872.n20 6.30833
R2566 a_n132_16872.n20 a_n132_16872.t37 1.99806
R2567 a_n132_16872.n20 a_n132_16872.t38 1.99806
R2568 a_n132_16872.n21 a_n132_16872.n19 6.62088
R2569 a_n132_16872.n19 a_n132_16872.t39 1.99806
R2570 a_n132_16872.n19 a_n132_16872.t40 1.99806
R2571 a_n132_16872.n11 a_n132_16872.n10 2.6005
R2572 a_n132_16872.n13 a_n132_16872.n12 2.6005
R2573 a_n132_16872.n15 a_n132_16872.n14 2.6005
R2574 a_n132_16872.n17 a_n132_16872.n16 2.6005
R2575 a_n132_16872.n11 a_n132_16872.n9 2.86434
R2576 a_n132_16872.n13 a_n132_16872.n11 0.276664
R2577 a_n132_16872.n15 a_n132_16872.n13 0.276664
R2578 a_n132_16872.n17 a_n132_16872.n15 0.276664
R2579 a_n132_16872.n18 a_n132_16872.n17 0.0855685
R2580 a_n132_16872.n16 a_n132_16872.t9 1.4923
R2581 a_n132_16872.n16 a_n132_16872.t10 2.06607
R2582 a_n132_16872.n14 a_n132_16872.t7 1.4923
R2583 a_n132_16872.n14 a_n132_16872.t8 2.06607
R2584 a_n132_16872.n12 a_n132_16872.t5 1.4923
R2585 a_n132_16872.n12 a_n132_16872.t6 2.06607
R2586 a_n132_16872.n10 a_n132_16872.t3 1.4923
R2587 a_n132_16872.n10 a_n132_16872.t4 2.06607
R2588 a_n132_16872.n9 a_n132_16872.t1 2.06607
R2589 a_n132_16872.n9 a_n132_16872.t2 1.4923
R2590 a_n132_16872.n7 a_n132_16872.t17 1.4923
R2591 a_n132_16872.n7 a_n132_16872.t18 2.06607
R2592 a_n132_16872.n5 a_n132_16872.t15 1.4923
R2593 a_n132_16872.n5 a_n132_16872.t16 2.06607
R2594 a_n132_16872.n3 a_n132_16872.t13 1.4923
R2595 a_n132_16872.n3 a_n132_16872.t14 2.06607
R2596 a_n132_16872.n1 a_n132_16872.t11 1.4923
R2597 a_n132_16872.n1 a_n132_16872.t12 2.06607
R2598 a_n132_19272.n0 a_n132_19272.t19 1.4923
R2599 a_n132_19272.t20 a_n132_19272.n0 2.06607
R2600 a_n132_19272.n2 a_n132_19272.n1 2.6005
R2601 a_n132_19272.n4 a_n132_19272.n3 2.6005
R2602 a_n132_19272.n6 a_n132_19272.n5 2.6005
R2603 a_n132_19272.n8 a_n132_19272.n7 2.6005
R2604 a_n132_19272.n2 a_n132_19272.n18 0.080637
R2605 a_n132_19272.n4 a_n132_19272.n2 0.276664
R2606 a_n132_19272.n6 a_n132_19272.n4 0.276664
R2607 a_n132_19272.n8 a_n132_19272.n6 0.276664
R2608 a_n132_19272.n0 a_n132_19272.n8 2.87666
R2609 a_n132_19272.n37 a_n132_19272.t0 82.8874
R2610 a_n132_19272.n18 a_n132_19272.n37 0.1455
R2611 a_n132_19272.n37 a_n132_19272.n20 0.105151
R2612 a_n132_19272.n20 a_n132_19272.n22 0.313058
R2613 a_n132_19272.n22 a_n132_19272.n24 0.313058
R2614 a_n132_19272.n24 a_n132_19272.n26 0.313058
R2615 a_n132_19272.n32 a_n132_19272.n30 0.313058
R2616 a_n132_19272.n34 a_n132_19272.n32 0.313058
R2617 a_n132_19272.n36 a_n132_19272.n34 0.313058
R2618 a_n132_19272.n37 a_n132_19272.n36 0.0828256
R2619 a_n132_19272.n36 a_n132_19272.n35 6.30833
R2620 a_n132_19272.n35 a_n132_19272.t29 1.99806
R2621 a_n132_19272.n35 a_n132_19272.t30 1.99806
R2622 a_n132_19272.n34 a_n132_19272.n33 6.30833
R2623 a_n132_19272.n33 a_n132_19272.t27 1.99806
R2624 a_n132_19272.n33 a_n132_19272.t28 1.99806
R2625 a_n132_19272.n32 a_n132_19272.n31 6.30833
R2626 a_n132_19272.n31 a_n132_19272.t25 1.99806
R2627 a_n132_19272.n31 a_n132_19272.t26 1.99806
R2628 a_n132_19272.n30 a_n132_19272.n29 6.30833
R2629 a_n132_19272.n29 a_n132_19272.t23 1.99806
R2630 a_n132_19272.n29 a_n132_19272.t24 1.99806
R2631 a_n132_19272.n30 a_n132_19272.n28 6.61789
R2632 a_n132_19272.n28 a_n132_19272.t21 1.99806
R2633 a_n132_19272.n28 a_n132_19272.t22 1.99806
R2634 a_n132_19272.n26 a_n132_19272.n27 6.62088
R2635 a_n132_19272.n27 a_n132_19272.t39 1.99806
R2636 a_n132_19272.n27 a_n132_19272.t40 1.99806
R2637 a_n132_19272.n26 a_n132_19272.n25 6.30833
R2638 a_n132_19272.n25 a_n132_19272.t37 1.99806
R2639 a_n132_19272.n25 a_n132_19272.t38 1.99806
R2640 a_n132_19272.n24 a_n132_19272.n23 6.30833
R2641 a_n132_19272.n23 a_n132_19272.t35 1.99806
R2642 a_n132_19272.n23 a_n132_19272.t36 1.99806
R2643 a_n132_19272.n22 a_n132_19272.n21 6.30833
R2644 a_n132_19272.n21 a_n132_19272.t33 1.99806
R2645 a_n132_19272.n21 a_n132_19272.t34 1.99806
R2646 a_n132_19272.n20 a_n132_19272.n19 6.30833
R2647 a_n132_19272.n19 a_n132_19272.t31 1.99806
R2648 a_n132_19272.n19 a_n132_19272.t32 1.99806
R2649 a_n132_19272.n11 a_n132_19272.n10 2.6005
R2650 a_n132_19272.n13 a_n132_19272.n12 2.6005
R2651 a_n132_19272.n15 a_n132_19272.n14 2.6005
R2652 a_n132_19272.n17 a_n132_19272.n16 2.6005
R2653 a_n132_19272.n11 a_n132_19272.n9 2.86434
R2654 a_n132_19272.n13 a_n132_19272.n11 0.276664
R2655 a_n132_19272.n15 a_n132_19272.n13 0.276664
R2656 a_n132_19272.n17 a_n132_19272.n15 0.276664
R2657 a_n132_19272.n18 a_n132_19272.n17 0.0855685
R2658 a_n132_19272.n16 a_n132_19272.t9 1.4923
R2659 a_n132_19272.n16 a_n132_19272.t10 2.06607
R2660 a_n132_19272.n14 a_n132_19272.t7 1.4923
R2661 a_n132_19272.n14 a_n132_19272.t8 2.06607
R2662 a_n132_19272.n12 a_n132_19272.t5 1.4923
R2663 a_n132_19272.n12 a_n132_19272.t6 2.06607
R2664 a_n132_19272.n10 a_n132_19272.t3 1.4923
R2665 a_n132_19272.n10 a_n132_19272.t4 2.06607
R2666 a_n132_19272.n9 a_n132_19272.t1 2.06607
R2667 a_n132_19272.n9 a_n132_19272.t2 1.4923
R2668 a_n132_19272.n7 a_n132_19272.t17 1.4923
R2669 a_n132_19272.n7 a_n132_19272.t18 2.06607
R2670 a_n132_19272.n5 a_n132_19272.t15 1.4923
R2671 a_n132_19272.n5 a_n132_19272.t16 2.06607
R2672 a_n132_19272.n3 a_n132_19272.t13 1.4923
R2673 a_n132_19272.n3 a_n132_19272.t14 2.06607
R2674 a_n132_19272.n1 a_n132_19272.t11 1.4923
R2675 a_n132_19272.n1 a_n132_19272.t12 2.06607
R2676 a_n132_21672.n0 a_n132_21672.t18 1.4923
R2677 a_n132_21672.t19 a_n132_21672.n0 2.06607
R2678 a_n132_21672.n2 a_n132_21672.n1 2.6005
R2679 a_n132_21672.n4 a_n132_21672.n3 2.6005
R2680 a_n132_21672.n6 a_n132_21672.n5 2.6005
R2681 a_n132_21672.n8 a_n132_21672.n7 2.6005
R2682 a_n132_21672.n2 a_n132_21672.n18 0.080637
R2683 a_n132_21672.n4 a_n132_21672.n2 0.276664
R2684 a_n132_21672.n6 a_n132_21672.n4 0.276664
R2685 a_n132_21672.n8 a_n132_21672.n6 0.276664
R2686 a_n132_21672.n0 a_n132_21672.n8 2.87666
R2687 a_n132_21672.n18 a_n132_21672.n37 0.145
R2688 a_n132_21672.n37 a_n132_21672.t40 84.3189
R2689 a_n132_21672.n37 a_n132_21672.n27 0.105151
R2690 a_n132_21672.n27 a_n132_21672.n25 0.313058
R2691 a_n132_21672.n25 a_n132_21672.n23 0.313058
R2692 a_n132_21672.n23 a_n132_21672.n21 0.313058
R2693 a_n132_21672.n33 a_n132_21672.n35 0.313058
R2694 a_n132_21672.n31 a_n132_21672.n33 0.313058
R2695 a_n132_21672.n29 a_n132_21672.n31 0.313058
R2696 a_n132_21672.n37 a_n132_21672.n29 0.0828256
R2697 a_n132_21672.n35 a_n132_21672.n36 6.61789
R2698 a_n132_21672.n36 a_n132_21672.t20 1.99806
R2699 a_n132_21672.n36 a_n132_21672.t21 1.99806
R2700 a_n132_21672.n35 a_n132_21672.n34 6.30833
R2701 a_n132_21672.n34 a_n132_21672.t22 1.99806
R2702 a_n132_21672.n34 a_n132_21672.t23 1.99806
R2703 a_n132_21672.n33 a_n132_21672.n32 6.30833
R2704 a_n132_21672.n32 a_n132_21672.t24 1.99806
R2705 a_n132_21672.n32 a_n132_21672.t25 1.99806
R2706 a_n132_21672.n31 a_n132_21672.n30 6.30833
R2707 a_n132_21672.n30 a_n132_21672.t26 1.99806
R2708 a_n132_21672.n30 a_n132_21672.t27 1.99806
R2709 a_n132_21672.n29 a_n132_21672.n28 6.30833
R2710 a_n132_21672.n28 a_n132_21672.t28 1.99806
R2711 a_n132_21672.n28 a_n132_21672.t29 1.99806
R2712 a_n132_21672.n27 a_n132_21672.n26 6.30833
R2713 a_n132_21672.n26 a_n132_21672.t30 1.99806
R2714 a_n132_21672.n26 a_n132_21672.t31 1.99806
R2715 a_n132_21672.n25 a_n132_21672.n24 6.30833
R2716 a_n132_21672.n24 a_n132_21672.t32 1.99806
R2717 a_n132_21672.n24 a_n132_21672.t33 1.99806
R2718 a_n132_21672.n23 a_n132_21672.n22 6.30833
R2719 a_n132_21672.n22 a_n132_21672.t34 1.99806
R2720 a_n132_21672.n22 a_n132_21672.t35 1.99806
R2721 a_n132_21672.n21 a_n132_21672.n20 6.30833
R2722 a_n132_21672.n20 a_n132_21672.t36 1.99806
R2723 a_n132_21672.n20 a_n132_21672.t37 1.99806
R2724 a_n132_21672.n21 a_n132_21672.n19 6.62088
R2725 a_n132_21672.n19 a_n132_21672.t38 1.99806
R2726 a_n132_21672.n19 a_n132_21672.t39 1.99806
R2727 a_n132_21672.n11 a_n132_21672.n10 2.6005
R2728 a_n132_21672.n13 a_n132_21672.n12 2.6005
R2729 a_n132_21672.n15 a_n132_21672.n14 2.6005
R2730 a_n132_21672.n17 a_n132_21672.n16 2.6005
R2731 a_n132_21672.n11 a_n132_21672.n9 2.86434
R2732 a_n132_21672.n13 a_n132_21672.n11 0.276664
R2733 a_n132_21672.n15 a_n132_21672.n13 0.276664
R2734 a_n132_21672.n17 a_n132_21672.n15 0.276664
R2735 a_n132_21672.n18 a_n132_21672.n17 0.0855685
R2736 a_n132_21672.n16 a_n132_21672.t8 1.4923
R2737 a_n132_21672.n16 a_n132_21672.t9 2.06607
R2738 a_n132_21672.n14 a_n132_21672.t6 1.4923
R2739 a_n132_21672.n14 a_n132_21672.t7 2.06607
R2740 a_n132_21672.n12 a_n132_21672.t4 1.4923
R2741 a_n132_21672.n12 a_n132_21672.t5 2.06607
R2742 a_n132_21672.n10 a_n132_21672.t2 1.4923
R2743 a_n132_21672.n10 a_n132_21672.t3 2.06607
R2744 a_n132_21672.n9 a_n132_21672.t0 2.06607
R2745 a_n132_21672.n9 a_n132_21672.t1 1.4923
R2746 a_n132_21672.n7 a_n132_21672.t16 1.4923
R2747 a_n132_21672.n7 a_n132_21672.t17 2.06607
R2748 a_n132_21672.n5 a_n132_21672.t14 1.4923
R2749 a_n132_21672.n5 a_n132_21672.t15 2.06607
R2750 a_n132_21672.n3 a_n132_21672.t12 1.4923
R2751 a_n132_21672.n3 a_n132_21672.t13 2.06607
R2752 a_n132_21672.n1 a_n132_21672.t10 1.4923
R2753 a_n132_21672.n1 a_n132_21672.t11 2.06607
R2754 a_n132_24072.n0 a_n132_24072.t18 1.4923
R2755 a_n132_24072.t19 a_n132_24072.n0 2.06607
R2756 a_n132_24072.n2 a_n132_24072.n1 2.6005
R2757 a_n132_24072.n4 a_n132_24072.n3 2.6005
R2758 a_n132_24072.n6 a_n132_24072.n5 2.6005
R2759 a_n132_24072.n8 a_n132_24072.n7 2.6005
R2760 a_n132_24072.n2 a_n132_24072.n18 0.080637
R2761 a_n132_24072.n4 a_n132_24072.n2 0.276664
R2762 a_n132_24072.n6 a_n132_24072.n4 0.276664
R2763 a_n132_24072.n8 a_n132_24072.n6 0.276664
R2764 a_n132_24072.n0 a_n132_24072.n8 2.87666
R2765 a_n132_24072.n37 a_n132_24072.t40 86.5234
R2766 a_n132_24072.n18 a_n132_24072.n37 0.1455
R2767 a_n132_24072.n37 a_n132_24072.n20 0.105151
R2768 a_n132_24072.n20 a_n132_24072.n22 0.313058
R2769 a_n132_24072.n22 a_n132_24072.n24 0.313058
R2770 a_n132_24072.n24 a_n132_24072.n26 0.313058
R2771 a_n132_24072.n32 a_n132_24072.n30 0.313058
R2772 a_n132_24072.n34 a_n132_24072.n32 0.313058
R2773 a_n132_24072.n36 a_n132_24072.n34 0.313058
R2774 a_n132_24072.n37 a_n132_24072.n36 0.0828256
R2775 a_n132_24072.n36 a_n132_24072.n35 6.30833
R2776 a_n132_24072.n35 a_n132_24072.t28 1.99806
R2777 a_n132_24072.n35 a_n132_24072.t29 1.99806
R2778 a_n132_24072.n34 a_n132_24072.n33 6.30833
R2779 a_n132_24072.n33 a_n132_24072.t26 1.99806
R2780 a_n132_24072.n33 a_n132_24072.t27 1.99806
R2781 a_n132_24072.n32 a_n132_24072.n31 6.30833
R2782 a_n132_24072.n31 a_n132_24072.t24 1.99806
R2783 a_n132_24072.n31 a_n132_24072.t25 1.99806
R2784 a_n132_24072.n30 a_n132_24072.n29 6.30833
R2785 a_n132_24072.n29 a_n132_24072.t22 1.99806
R2786 a_n132_24072.n29 a_n132_24072.t23 1.99806
R2787 a_n132_24072.n30 a_n132_24072.n28 6.61789
R2788 a_n132_24072.n28 a_n132_24072.t20 1.99806
R2789 a_n132_24072.n28 a_n132_24072.t21 1.99806
R2790 a_n132_24072.n26 a_n132_24072.n27 6.62088
R2791 a_n132_24072.n27 a_n132_24072.t38 1.99806
R2792 a_n132_24072.n27 a_n132_24072.t39 1.99806
R2793 a_n132_24072.n26 a_n132_24072.n25 6.30833
R2794 a_n132_24072.n25 a_n132_24072.t36 1.99806
R2795 a_n132_24072.n25 a_n132_24072.t37 1.99806
R2796 a_n132_24072.n24 a_n132_24072.n23 6.30833
R2797 a_n132_24072.n23 a_n132_24072.t34 1.99806
R2798 a_n132_24072.n23 a_n132_24072.t35 1.99806
R2799 a_n132_24072.n22 a_n132_24072.n21 6.30833
R2800 a_n132_24072.n21 a_n132_24072.t32 1.99806
R2801 a_n132_24072.n21 a_n132_24072.t33 1.99806
R2802 a_n132_24072.n20 a_n132_24072.n19 6.30833
R2803 a_n132_24072.n19 a_n132_24072.t30 1.99806
R2804 a_n132_24072.n19 a_n132_24072.t31 1.99806
R2805 a_n132_24072.n11 a_n132_24072.n10 2.6005
R2806 a_n132_24072.n13 a_n132_24072.n12 2.6005
R2807 a_n132_24072.n15 a_n132_24072.n14 2.6005
R2808 a_n132_24072.n17 a_n132_24072.n16 2.6005
R2809 a_n132_24072.n11 a_n132_24072.n9 2.86434
R2810 a_n132_24072.n13 a_n132_24072.n11 0.276664
R2811 a_n132_24072.n15 a_n132_24072.n13 0.276664
R2812 a_n132_24072.n17 a_n132_24072.n15 0.276664
R2813 a_n132_24072.n18 a_n132_24072.n17 0.0855685
R2814 a_n132_24072.n16 a_n132_24072.t8 1.4923
R2815 a_n132_24072.n16 a_n132_24072.t9 2.06607
R2816 a_n132_24072.n14 a_n132_24072.t6 1.4923
R2817 a_n132_24072.n14 a_n132_24072.t7 2.06607
R2818 a_n132_24072.n12 a_n132_24072.t4 1.4923
R2819 a_n132_24072.n12 a_n132_24072.t5 2.06607
R2820 a_n132_24072.n10 a_n132_24072.t2 1.4923
R2821 a_n132_24072.n10 a_n132_24072.t3 2.06607
R2822 a_n132_24072.n9 a_n132_24072.t0 2.06607
R2823 a_n132_24072.n9 a_n132_24072.t1 1.4923
R2824 a_n132_24072.n7 a_n132_24072.t16 1.4923
R2825 a_n132_24072.n7 a_n132_24072.t17 2.06607
R2826 a_n132_24072.n5 a_n132_24072.t14 1.4923
R2827 a_n132_24072.n5 a_n132_24072.t15 2.06607
R2828 a_n132_24072.n3 a_n132_24072.t12 1.4923
R2829 a_n132_24072.n3 a_n132_24072.t13 2.06607
R2830 a_n132_24072.n1 a_n132_24072.t10 1.4923
R2831 a_n132_24072.n1 a_n132_24072.t11 2.06607
R2832 a_n132_26472.n0 a_n132_26472.t18 1.4923
R2833 a_n132_26472.t19 a_n132_26472.n0 2.06607
R2834 a_n132_26472.n2 a_n132_26472.n1 2.6005
R2835 a_n132_26472.n4 a_n132_26472.n3 2.6005
R2836 a_n132_26472.n6 a_n132_26472.n5 2.6005
R2837 a_n132_26472.n8 a_n132_26472.n7 2.6005
R2838 a_n132_26472.n2 a_n132_26472.n18 0.080637
R2839 a_n132_26472.n4 a_n132_26472.n2 0.276664
R2840 a_n132_26472.n6 a_n132_26472.n4 0.276664
R2841 a_n132_26472.n8 a_n132_26472.n6 0.276664
R2842 a_n132_26472.n0 a_n132_26472.n8 2.87666
R2843 a_n132_26472.n18 a_n132_26472.n37 0.145
R2844 a_n132_26472.n37 a_n132_26472.t40 87.9549
R2845 a_n132_26472.n37 a_n132_26472.n27 0.105151
R2846 a_n132_26472.n27 a_n132_26472.n25 0.313058
R2847 a_n132_26472.n25 a_n132_26472.n23 0.313058
R2848 a_n132_26472.n23 a_n132_26472.n21 0.313058
R2849 a_n132_26472.n33 a_n132_26472.n35 0.313058
R2850 a_n132_26472.n31 a_n132_26472.n33 0.313058
R2851 a_n132_26472.n29 a_n132_26472.n31 0.313058
R2852 a_n132_26472.n37 a_n132_26472.n29 0.0828256
R2853 a_n132_26472.n35 a_n132_26472.n36 6.61789
R2854 a_n132_26472.n36 a_n132_26472.t20 1.99806
R2855 a_n132_26472.n36 a_n132_26472.t21 1.99806
R2856 a_n132_26472.n35 a_n132_26472.n34 6.30833
R2857 a_n132_26472.n34 a_n132_26472.t22 1.99806
R2858 a_n132_26472.n34 a_n132_26472.t23 1.99806
R2859 a_n132_26472.n33 a_n132_26472.n32 6.30833
R2860 a_n132_26472.n32 a_n132_26472.t24 1.99806
R2861 a_n132_26472.n32 a_n132_26472.t25 1.99806
R2862 a_n132_26472.n31 a_n132_26472.n30 6.30833
R2863 a_n132_26472.n30 a_n132_26472.t26 1.99806
R2864 a_n132_26472.n30 a_n132_26472.t27 1.99806
R2865 a_n132_26472.n29 a_n132_26472.n28 6.30833
R2866 a_n132_26472.n28 a_n132_26472.t28 1.99806
R2867 a_n132_26472.n28 a_n132_26472.t29 1.99806
R2868 a_n132_26472.n27 a_n132_26472.n26 6.30833
R2869 a_n132_26472.n26 a_n132_26472.t30 1.99806
R2870 a_n132_26472.n26 a_n132_26472.t31 1.99806
R2871 a_n132_26472.n25 a_n132_26472.n24 6.30833
R2872 a_n132_26472.n24 a_n132_26472.t32 1.99806
R2873 a_n132_26472.n24 a_n132_26472.t33 1.99806
R2874 a_n132_26472.n23 a_n132_26472.n22 6.30833
R2875 a_n132_26472.n22 a_n132_26472.t34 1.99806
R2876 a_n132_26472.n22 a_n132_26472.t35 1.99806
R2877 a_n132_26472.n21 a_n132_26472.n20 6.30833
R2878 a_n132_26472.n20 a_n132_26472.t36 1.99806
R2879 a_n132_26472.n20 a_n132_26472.t37 1.99806
R2880 a_n132_26472.n21 a_n132_26472.n19 6.62088
R2881 a_n132_26472.n19 a_n132_26472.t38 1.99806
R2882 a_n132_26472.n19 a_n132_26472.t39 1.99806
R2883 a_n132_26472.n11 a_n132_26472.n10 2.6005
R2884 a_n132_26472.n13 a_n132_26472.n12 2.6005
R2885 a_n132_26472.n15 a_n132_26472.n14 2.6005
R2886 a_n132_26472.n17 a_n132_26472.n16 2.6005
R2887 a_n132_26472.n11 a_n132_26472.n9 2.86434
R2888 a_n132_26472.n13 a_n132_26472.n11 0.276664
R2889 a_n132_26472.n15 a_n132_26472.n13 0.276664
R2890 a_n132_26472.n17 a_n132_26472.n15 0.276664
R2891 a_n132_26472.n18 a_n132_26472.n17 0.0855685
R2892 a_n132_26472.n16 a_n132_26472.t8 1.4923
R2893 a_n132_26472.n16 a_n132_26472.t9 2.06607
R2894 a_n132_26472.n14 a_n132_26472.t6 1.4923
R2895 a_n132_26472.n14 a_n132_26472.t7 2.06607
R2896 a_n132_26472.n12 a_n132_26472.t4 1.4923
R2897 a_n132_26472.n12 a_n132_26472.t5 2.06607
R2898 a_n132_26472.n10 a_n132_26472.t2 1.4923
R2899 a_n132_26472.n10 a_n132_26472.t3 2.06607
R2900 a_n132_26472.n9 a_n132_26472.t0 2.06607
R2901 a_n132_26472.n9 a_n132_26472.t1 1.4923
R2902 a_n132_26472.n7 a_n132_26472.t16 1.4923
R2903 a_n132_26472.n7 a_n132_26472.t17 2.06607
R2904 a_n132_26472.n5 a_n132_26472.t14 1.4923
R2905 a_n132_26472.n5 a_n132_26472.t15 2.06607
R2906 a_n132_26472.n3 a_n132_26472.t12 1.4923
R2907 a_n132_26472.n3 a_n132_26472.t13 2.06607
R2908 a_n132_26472.n1 a_n132_26472.t10 1.4923
R2909 a_n132_26472.n1 a_n132_26472.t11 2.06607
C0 vdd a_29672_25672# 0.01646f
C1 a_n132_10472# a_29672_11272# 0.4694f
C2 a_n132_15272# a_29672_13672# 0.00207f
C3 a_29672_16072# a_n132_12872# 0.00593f
C4 vdd vout 0.17171f
C5 a_n132_15272# a_n132_12872# 0.13395f
C6 a_n132_20072# a_29672_20872# 0.4694f
C7 a_n132_8072# a_29672_11272# 0.00593f
C8 a_29672_8872# a_n132_10472# 0
C9 a_n132_8072# a_n132_10472# 0.13395f
C10 a_n132_22472# a_29672_23272# 0.53362f
C11 a_n132_12872# a_29672_11272# 0.00207f
C12 a_29672_13672# a_n132_10472# 0.012f
C13 a_n132_12872# a_n132_10472# 0.13539f
C14 a_29672_8872# a_n132_7272# 0.06069f
C15 a_n132_8072# a_29672_8872# 0.36852f
C16 a_n132_22472# a_29672_25672# 0.00593f
C17 vout a_29672_23272# 0.00207f
C18 a_n132_8072# a_n132_7272# 1.0588f
C19 a_n132_20072# a_29672_18472# 0.00207f
C20 a_29672_20872# a_n132_17672# 0.00593f
C21 vout a_n132_22472# 0.13395f
C22 a_n132_20072# a_n132_17672# 0.13395f
C23 vout a_29672_25672# 0.33645f
C24 vdd dac_code[4] 2.09713f
C25 a_n132_12872# a_29672_13672# 0.53362f
C26 a_n132_15272# a_29672_16072# 0.4694f
C27 vdd dac_code[5] 2.09713f
C28 dac_code[5] dac_code[4] 0.35899f
C29 vdd dac_code[6] 2.09713f
C30 vdd dac_code[7] 2.09713f
C31 dac_code[6] dac_code[5] 0.28478f
C32 vdd dac_code[0] 2.04263f
C33 a_n132_15272# a_29672_18472# 0.012f
C34 a_29672_16072# a_n132_17672# 0.00207f
C35 vdd dac_code[1] 2.09713f
C36 dac_code[7] dac_code[6] 0.35899f
C37 vdd dac_code[2] 2.09713f
C38 vdd dac_code[3] 2.09713f
C39 dac_code[4] dac_code[3] 0.28478f
C40 a_n132_15272# a_n132_17672# 0.13539f
C41 a_n132_17672# a_29672_18472# 0.53362f
C42 dac_code[1] dac_code[0] 0.35899f
C43 a_29672_23272# a_n132_20072# 0.012f
C44 a_n132_22472# a_29672_20872# 0.00207f
C45 dac_code[2] dac_code[1] 0.28478f
C46 a_n132_22472# a_n132_20072# 0.13539f
C47 dac_code[3] dac_code[2] 0.35899f
C48 dac_code[0] vss 3.94748f
C49 dac_code[1] vss 3.4974f
C50 dac_code[2] vss 3.48699f
C51 dac_code[3] vss 3.48699f
C52 dac_code[4] vss 3.48699f
C53 dac_code[5] vss 3.48699f
C54 dac_code[6] vss 3.48605f
C55 dac_code[7] vss 3.97448f
C56 vout vss 16.00413f
C57 vdd vss 0.11001p
C58 a_n132_7272# vss 9.55236f
C59 a_29672_8872# vss 1.85791f
C60 a_n132_8072# vss 12.6404f
C61 a_29672_11272# vss 1.27863f
C62 a_n132_10472# vss 12.6447f
C63 a_29672_13672# vss 1.25416f
C64 a_n132_12872# vss 12.7387f
C65 a_29672_16072# vss 1.2814f
C66 a_n132_15272# vss 12.8182f
C67 a_29672_18472# vss 1.29834f
C68 a_n132_17672# vss 12.7765f
C69 a_29672_20872# vss 1.28295f
C70 a_n132_20072# vss 12.8831f
C71 a_29672_23272# vss 1.3161f
C72 a_n132_22472# vss 12.7969f
C73 a_29672_25672# vss 1.3913f
C74 a_n132_26472.t19 vss 0.09393f
C75 a_n132_26472.n0 vss 0.04579f
C76 a_n132_26472.t10 vss 0.08748f
C77 a_n132_26472.t11 vss 0.09339f
C78 a_n132_26472.n1 vss 0.0366f
C79 a_n132_26472.n2 vss 0.11055f
C80 a_n132_26472.t12 vss 0.08748f
C81 a_n132_26472.t13 vss 0.09339f
C82 a_n132_26472.n3 vss 0.0366f
C83 a_n132_26472.n4 vss 0.16671f
C84 a_n132_26472.t14 vss 0.08748f
C85 a_n132_26472.t15 vss 0.09339f
C86 a_n132_26472.n5 vss 0.0366f
C87 a_n132_26472.n6 vss 0.16671f
C88 a_n132_26472.t16 vss 0.08748f
C89 a_n132_26472.t17 vss 0.09339f
C90 a_n132_26472.n7 vss 0.0366f
C91 a_n132_26472.n8 vss 0.25324f
C92 a_n132_26472.t0 vss 0.09339f
C93 a_n132_26472.t1 vss 0.08748f
C94 a_n132_26472.n9 vss 0.04509f
C95 a_n132_26472.t2 vss 0.08748f
C96 a_n132_26472.t3 vss 0.09339f
C97 a_n132_26472.n10 vss 0.0366f
C98 a_n132_26472.n11 vss 0.24687f
C99 a_n132_26472.t4 vss 0.08748f
C100 a_n132_26472.t5 vss 0.09339f
C101 a_n132_26472.n12 vss 0.0366f
C102 a_n132_26472.n13 vss 0.16671f
C103 a_n132_26472.t6 vss 0.08748f
C104 a_n132_26472.t7 vss 0.09339f
C105 a_n132_26472.n14 vss 0.0366f
C106 a_n132_26472.n15 vss 0.16671f
C107 a_n132_26472.t8 vss 0.08748f
C108 a_n132_26472.t9 vss 0.09339f
C109 a_n132_26472.n16 vss 0.0366f
C110 a_n132_26472.n17 vss 0.11196f
C111 a_n132_26472.n18 vss 0.14206f
C112 a_n132_26472.t40 vss 5.87416f
C113 a_n132_26472.t38 vss 0.08465f
C114 a_n132_26472.t39 vss 0.08544f
C115 a_n132_26472.n19 vss 0.02448f
C116 a_n132_26472.t36 vss 0.08465f
C117 a_n132_26472.t37 vss 0.08465f
C118 a_n132_26472.n20 vss 0.02064f
C119 a_n132_26472.n21 vss 0.22153f
C120 a_n132_26472.t34 vss 0.08465f
C121 a_n132_26472.t35 vss 0.08465f
C122 a_n132_26472.n22 vss 0.02064f
C123 a_n132_26472.n23 vss 0.14405f
C124 a_n132_26472.t32 vss 0.08465f
C125 a_n132_26472.t33 vss 0.08465f
C126 a_n132_26472.n24 vss 0.02064f
C127 a_n132_26472.n25 vss 0.14405f
C128 a_n132_26472.t30 vss 0.08465f
C129 a_n132_26472.t31 vss 0.08465f
C130 a_n132_26472.n26 vss 0.02064f
C131 a_n132_26472.n27 vss 0.09755f
C132 a_n132_26472.t28 vss 0.08465f
C133 a_n132_26472.t29 vss 0.08465f
C134 a_n132_26472.n28 vss 0.02064f
C135 a_n132_26472.n29 vss 0.09255f
C136 a_n132_26472.t26 vss 0.08465f
C137 a_n132_26472.t27 vss 0.08465f
C138 a_n132_26472.n30 vss 0.02064f
C139 a_n132_26472.n31 vss 0.14405f
C140 a_n132_26472.t24 vss 0.08465f
C141 a_n132_26472.t25 vss 0.08465f
C142 a_n132_26472.n32 vss 0.02064f
C143 a_n132_26472.n33 vss 0.14405f
C144 a_n132_26472.t22 vss 0.08465f
C145 a_n132_26472.t23 vss 0.08465f
C146 a_n132_26472.n34 vss 0.02064f
C147 a_n132_26472.n35 vss 0.22206f
C148 a_n132_26472.t20 vss 0.08465f
C149 a_n132_26472.t21 vss 0.08465f
C150 a_n132_26472.n36 vss 0.0245f
C151 a_n132_26472.n37 vss 5.8358f
C152 a_n132_26472.t18 vss 0.08748f
C153 a_n132_24072.t19 vss 0.10076f
C154 a_n132_24072.n0 vss 0.0552f
C155 a_n132_24072.t10 vss 0.09307f
C156 a_n132_24072.t11 vss 0.10019f
C157 a_n132_24072.n1 vss 0.04412f
C158 a_n132_24072.n2 vss 0.13325f
C159 a_n132_24072.t12 vss 0.09307f
C160 a_n132_24072.t13 vss 0.10019f
C161 a_n132_24072.n3 vss 0.04412f
C162 a_n132_24072.n4 vss 0.20095f
C163 a_n132_24072.t14 vss 0.09307f
C164 a_n132_24072.t15 vss 0.10019f
C165 a_n132_24072.n5 vss 0.04412f
C166 a_n132_24072.n6 vss 0.20095f
C167 a_n132_24072.t16 vss 0.09307f
C168 a_n132_24072.t17 vss 0.10019f
C169 a_n132_24072.n7 vss 0.04412f
C170 a_n132_24072.n8 vss 0.30525f
C171 a_n132_24072.t0 vss 0.10019f
C172 a_n132_24072.t1 vss 0.09307f
C173 a_n132_24072.n9 vss 0.05436f
C174 a_n132_24072.t2 vss 0.09307f
C175 a_n132_24072.t3 vss 0.10019f
C176 a_n132_24072.n10 vss 0.04412f
C177 a_n132_24072.n11 vss 0.29757f
C178 a_n132_24072.t4 vss 0.09307f
C179 a_n132_24072.t5 vss 0.10019f
C180 a_n132_24072.n12 vss 0.04412f
C181 a_n132_24072.n13 vss 0.20095f
C182 a_n132_24072.t6 vss 0.09307f
C183 a_n132_24072.t7 vss 0.10019f
C184 a_n132_24072.n14 vss 0.04412f
C185 a_n132_24072.n15 vss 0.20095f
C186 a_n132_24072.t8 vss 0.09307f
C187 a_n132_24072.t9 vss 0.10019f
C188 a_n132_24072.n16 vss 0.04412f
C189 a_n132_24072.n17 vss 0.13496f
C190 a_n132_24072.n18 vss 0.1715f
C191 a_n132_24072.t40 vss 6.93412f
C192 a_n132_24072.t30 vss 0.08928f
C193 a_n132_24072.t31 vss 0.08928f
C194 a_n132_24072.n19 vss 0.02488f
C195 a_n132_24072.n20 vss 0.11758f
C196 a_n132_24072.t32 vss 0.08928f
C197 a_n132_24072.t33 vss 0.08928f
C198 a_n132_24072.n21 vss 0.02488f
C199 a_n132_24072.n22 vss 0.17364f
C200 a_n132_24072.t34 vss 0.08928f
C201 a_n132_24072.t35 vss 0.08928f
C202 a_n132_24072.n23 vss 0.02488f
C203 a_n132_24072.n24 vss 0.17364f
C204 a_n132_24072.t36 vss 0.08928f
C205 a_n132_24072.t37 vss 0.08928f
C206 a_n132_24072.n25 vss 0.02488f
C207 a_n132_24072.n26 vss 0.26703f
C208 a_n132_24072.t38 vss 0.08928f
C209 a_n132_24072.t39 vss 0.09009f
C210 a_n132_24072.n27 vss 0.0295f
C211 a_n132_24072.t20 vss 0.08928f
C212 a_n132_24072.t21 vss 0.08928f
C213 a_n132_24072.n28 vss 0.02953f
C214 a_n132_24072.t22 vss 0.08928f
C215 a_n132_24072.t23 vss 0.08928f
C216 a_n132_24072.n29 vss 0.02488f
C217 a_n132_24072.n30 vss 0.26766f
C218 a_n132_24072.t24 vss 0.08928f
C219 a_n132_24072.t25 vss 0.08928f
C220 a_n132_24072.n31 vss 0.02488f
C221 a_n132_24072.n32 vss 0.17364f
C222 a_n132_24072.t26 vss 0.08928f
C223 a_n132_24072.t27 vss 0.08928f
C224 a_n132_24072.n33 vss 0.02488f
C225 a_n132_24072.n34 vss 0.17364f
C226 a_n132_24072.t28 vss 0.08928f
C227 a_n132_24072.t29 vss 0.08928f
C228 a_n132_24072.n35 vss 0.02488f
C229 a_n132_24072.n36 vss 0.11156f
C230 a_n132_24072.n37 vss 6.88378f
C231 a_n132_24072.t18 vss 0.09307f
C232 a_n132_21672.t19 vss 0.10052f
C233 a_n132_21672.n0 vss 0.0547f
C234 a_n132_21672.t10 vss 0.09291f
C235 a_n132_21672.t11 vss 0.09996f
C236 a_n132_21672.n1 vss 0.04372f
C237 a_n132_21672.n2 vss 0.13205f
C238 a_n132_21672.t12 vss 0.09291f
C239 a_n132_21672.t13 vss 0.09996f
C240 a_n132_21672.n3 vss 0.04372f
C241 a_n132_21672.n4 vss 0.19914f
C242 a_n132_21672.t14 vss 0.09291f
C243 a_n132_21672.t15 vss 0.09996f
C244 a_n132_21672.n5 vss 0.04372f
C245 a_n132_21672.n6 vss 0.19914f
C246 a_n132_21672.t16 vss 0.09291f
C247 a_n132_21672.t17 vss 0.09996f
C248 a_n132_21672.n7 vss 0.04372f
C249 a_n132_21672.n8 vss 0.30248f
C250 a_n132_21672.t0 vss 0.09996f
C251 a_n132_21672.t1 vss 0.09291f
C252 a_n132_21672.n9 vss 0.05386f
C253 a_n132_21672.t2 vss 0.09291f
C254 a_n132_21672.t3 vss 0.09996f
C255 a_n132_21672.n10 vss 0.04372f
C256 a_n132_21672.n11 vss 0.29488f
C257 a_n132_21672.t4 vss 0.09291f
C258 a_n132_21672.t5 vss 0.09996f
C259 a_n132_21672.n12 vss 0.04372f
C260 a_n132_21672.n13 vss 0.19914f
C261 a_n132_21672.t6 vss 0.09291f
C262 a_n132_21672.t7 vss 0.09996f
C263 a_n132_21672.n14 vss 0.04372f
C264 a_n132_21672.n15 vss 0.19914f
C265 a_n132_21672.t8 vss 0.09291f
C266 a_n132_21672.t9 vss 0.09996f
C267 a_n132_21672.n16 vss 0.04372f
C268 a_n132_21672.n17 vss 0.13373f
C269 a_n132_21672.n18 vss 0.16969f
C270 a_n132_21672.t40 vss 6.65058f
C271 a_n132_21672.t38 vss 0.08917f
C272 a_n132_21672.t39 vss 0.08998f
C273 a_n132_21672.n19 vss 0.02924f
C274 a_n132_21672.t36 vss 0.08917f
C275 a_n132_21672.t37 vss 0.08917f
C276 a_n132_21672.n20 vss 0.02465f
C277 a_n132_21672.n21 vss 0.26461f
C278 a_n132_21672.t34 vss 0.08917f
C279 a_n132_21672.t35 vss 0.08917f
C280 a_n132_21672.n22 vss 0.02465f
C281 a_n132_21672.n23 vss 0.17207f
C282 a_n132_21672.t32 vss 0.08917f
C283 a_n132_21672.t33 vss 0.08917f
C284 a_n132_21672.n24 vss 0.02465f
C285 a_n132_21672.n25 vss 0.17207f
C286 a_n132_21672.t30 vss 0.08917f
C287 a_n132_21672.t31 vss 0.08917f
C288 a_n132_21672.n26 vss 0.02465f
C289 a_n132_21672.n27 vss 0.11652f
C290 a_n132_21672.t28 vss 0.08917f
C291 a_n132_21672.t29 vss 0.08917f
C292 a_n132_21672.n28 vss 0.02465f
C293 a_n132_21672.n29 vss 0.11055f
C294 a_n132_21672.t26 vss 0.08917f
C295 a_n132_21672.t27 vss 0.08917f
C296 a_n132_21672.n30 vss 0.02465f
C297 a_n132_21672.n31 vss 0.17207f
C298 a_n132_21672.t24 vss 0.08917f
C299 a_n132_21672.t25 vss 0.08917f
C300 a_n132_21672.n32 vss 0.02465f
C301 a_n132_21672.n33 vss 0.17207f
C302 a_n132_21672.t22 vss 0.08917f
C303 a_n132_21672.t23 vss 0.08917f
C304 a_n132_21672.n34 vss 0.02465f
C305 a_n132_21672.n35 vss 0.26524f
C306 a_n132_21672.t20 vss 0.08917f
C307 a_n132_21672.t21 vss 0.08917f
C308 a_n132_21672.n36 vss 0.02927f
C309 a_n132_21672.n37 vss 6.58941f
C310 a_n132_21672.t18 vss 0.09291f
C311 a_n132_19272.t20 vss 0.10016f
C312 a_n132_19272.n0 vss 0.05392f
C313 a_n132_19272.t11 vss 0.09265f
C314 a_n132_19272.t12 vss 0.0996f
C315 a_n132_19272.n1 vss 0.0431f
C316 a_n132_19272.n2 vss 0.13017f
C317 a_n132_19272.t13 vss 0.09265f
C318 a_n132_19272.t14 vss 0.0996f
C319 a_n132_19272.n3 vss 0.0431f
C320 a_n132_19272.n4 vss 0.19631f
C321 a_n132_19272.t15 vss 0.09265f
C322 a_n132_19272.t16 vss 0.0996f
C323 a_n132_19272.n5 vss 0.0431f
C324 a_n132_19272.n6 vss 0.19631f
C325 a_n132_19272.t17 vss 0.09265f
C326 a_n132_19272.t18 vss 0.0996f
C327 a_n132_19272.n7 vss 0.0431f
C328 a_n132_19272.n8 vss 0.29819f
C329 a_n132_19272.t1 vss 0.0996f
C330 a_n132_19272.t2 vss 0.09265f
C331 a_n132_19272.n9 vss 0.0531f
C332 a_n132_19272.t3 vss 0.09265f
C333 a_n132_19272.t4 vss 0.0996f
C334 a_n132_19272.n10 vss 0.0431f
C335 a_n132_19272.n11 vss 0.29069f
C336 a_n132_19272.t5 vss 0.09265f
C337 a_n132_19272.t6 vss 0.0996f
C338 a_n132_19272.n12 vss 0.0431f
C339 a_n132_19272.n13 vss 0.19631f
C340 a_n132_19272.t7 vss 0.09265f
C341 a_n132_19272.t8 vss 0.0996f
C342 a_n132_19272.n14 vss 0.0431f
C343 a_n132_19272.n15 vss 0.19631f
C344 a_n132_19272.t9 vss 0.09265f
C345 a_n132_19272.t10 vss 0.0996f
C346 a_n132_19272.n16 vss 0.0431f
C347 a_n132_19272.n17 vss 0.13184f
C348 a_n132_19272.n18 vss 0.16754f
C349 a_n132_19272.t0 vss 6.41335f
C350 a_n132_19272.t31 vss 0.08899f
C351 a_n132_19272.t32 vss 0.08899f
C352 a_n132_19272.n19 vss 0.0243f
C353 a_n132_19272.n20 vss 0.11486f
C354 a_n132_19272.t33 vss 0.08899f
C355 a_n132_19272.t34 vss 0.08899f
C356 a_n132_19272.n21 vss 0.0243f
C357 a_n132_19272.n22 vss 0.16963f
C358 a_n132_19272.t35 vss 0.08899f
C359 a_n132_19272.t36 vss 0.08899f
C360 a_n132_19272.n23 vss 0.0243f
C361 a_n132_19272.n24 vss 0.16963f
C362 a_n132_19272.t37 vss 0.08899f
C363 a_n132_19272.t38 vss 0.08899f
C364 a_n132_19272.n25 vss 0.0243f
C365 a_n132_19272.n26 vss 0.26086f
C366 a_n132_19272.t39 vss 0.08899f
C367 a_n132_19272.t40 vss 0.08981f
C368 a_n132_19272.n27 vss 0.02882f
C369 a_n132_19272.t21 vss 0.08899f
C370 a_n132_19272.t22 vss 0.08899f
C371 a_n132_19272.n28 vss 0.02885f
C372 a_n132_19272.t23 vss 0.08899f
C373 a_n132_19272.t24 vss 0.08899f
C374 a_n132_19272.n29 vss 0.0243f
C375 a_n132_19272.n30 vss 0.26148f
C376 a_n132_19272.t25 vss 0.08899f
C377 a_n132_19272.t26 vss 0.08899f
C378 a_n132_19272.n31 vss 0.0243f
C379 a_n132_19272.n32 vss 0.16963f
C380 a_n132_19272.t27 vss 0.08899f
C381 a_n132_19272.t28 vss 0.08899f
C382 a_n132_19272.n33 vss 0.0243f
C383 a_n132_19272.n34 vss 0.16963f
C384 a_n132_19272.t29 vss 0.08899f
C385 a_n132_19272.t30 vss 0.08899f
C386 a_n132_19272.n35 vss 0.0243f
C387 a_n132_19272.n36 vss 0.10898f
C388 a_n132_19272.n37 vss 6.3486f
C389 a_n132_19272.t19 vss 0.09265f
C390 a_n132_16872.t20 vss 0.09997f
C391 a_n132_16872.n0 vss 0.05351f
C392 a_n132_16872.t11 vss 0.09251f
C393 a_n132_16872.t12 vss 0.09941f
C394 a_n132_16872.n1 vss 0.04277f
C395 a_n132_16872.n2 vss 0.12918f
C396 a_n132_16872.t13 vss 0.09251f
C397 a_n132_16872.t14 vss 0.09941f
C398 a_n132_16872.n3 vss 0.04277f
C399 a_n132_16872.n4 vss 0.19481f
C400 a_n132_16872.t15 vss 0.09251f
C401 a_n132_16872.t16 vss 0.09941f
C402 a_n132_16872.n5 vss 0.04277f
C403 a_n132_16872.n6 vss 0.19481f
C404 a_n132_16872.t17 vss 0.09251f
C405 a_n132_16872.t18 vss 0.09941f
C406 a_n132_16872.n7 vss 0.04277f
C407 a_n132_16872.n8 vss 0.29591f
C408 a_n132_16872.t1 vss 0.09941f
C409 a_n132_16872.t2 vss 0.09251f
C410 a_n132_16872.n9 vss 0.05269f
C411 a_n132_16872.t3 vss 0.09251f
C412 a_n132_16872.t4 vss 0.09941f
C413 a_n132_16872.n10 vss 0.04277f
C414 a_n132_16872.n11 vss 0.28847f
C415 a_n132_16872.t5 vss 0.09251f
C416 a_n132_16872.t6 vss 0.09941f
C417 a_n132_16872.n12 vss 0.04277f
C418 a_n132_16872.n13 vss 0.19481f
C419 a_n132_16872.t7 vss 0.09251f
C420 a_n132_16872.t8 vss 0.09941f
C421 a_n132_16872.n14 vss 0.04277f
C422 a_n132_16872.n15 vss 0.19481f
C423 a_n132_16872.t9 vss 0.09251f
C424 a_n132_16872.t10 vss 0.09941f
C425 a_n132_16872.n16 vss 0.04277f
C426 a_n132_16872.n17 vss 0.13083f
C427 a_n132_16872.n18 vss 0.166f
C428 a_n132_16872.t0 vss 6.14879f
C429 a_n132_16872.t39 vss 0.0889f
C430 a_n132_16872.t40 vss 0.08971f
C431 a_n132_16872.n19 vss 0.0286f
C432 a_n132_16872.t37 vss 0.0889f
C433 a_n132_16872.t38 vss 0.0889f
C434 a_n132_16872.n20 vss 0.02412f
C435 a_n132_16872.n21 vss 0.25886f
C436 a_n132_16872.t35 vss 0.0889f
C437 a_n132_16872.t36 vss 0.0889f
C438 a_n132_16872.n22 vss 0.02412f
C439 a_n132_16872.n23 vss 0.16833f
C440 a_n132_16872.t33 vss 0.0889f
C441 a_n132_16872.t34 vss 0.0889f
C442 a_n132_16872.n24 vss 0.02412f
C443 a_n132_16872.n25 vss 0.16833f
C444 a_n132_16872.t31 vss 0.0889f
C445 a_n132_16872.t32 vss 0.0889f
C446 a_n132_16872.n26 vss 0.02412f
C447 a_n132_16872.n27 vss 0.11399f
C448 a_n132_16872.t29 vss 0.0889f
C449 a_n132_16872.t30 vss 0.0889f
C450 a_n132_16872.n28 vss 0.02412f
C451 a_n132_16872.n29 vss 0.10815f
C452 a_n132_16872.t27 vss 0.0889f
C453 a_n132_16872.t28 vss 0.0889f
C454 a_n132_16872.n30 vss 0.02412f
C455 a_n132_16872.n31 vss 0.16833f
C456 a_n132_16872.t25 vss 0.0889f
C457 a_n132_16872.t26 vss 0.0889f
C458 a_n132_16872.n32 vss 0.02412f
C459 a_n132_16872.n33 vss 0.16833f
C460 a_n132_16872.t23 vss 0.0889f
C461 a_n132_16872.t24 vss 0.0889f
C462 a_n132_16872.n34 vss 0.02412f
C463 a_n132_16872.n35 vss 0.25948f
C464 a_n132_16872.t21 vss 0.0889f
C465 a_n132_16872.t22 vss 0.0889f
C466 a_n132_16872.n36 vss 0.02863f
C467 a_n132_16872.n37 vss 6.07256f
C468 a_n132_16872.t19 vss 0.09251f
C469 a_n132_14472.t20 vss 0.09963f
C470 a_n132_14472.n0 vss 0.05278f
C471 a_n132_14472.t11 vss 0.09226f
C472 a_n132_14472.t12 vss 0.09907f
C473 a_n132_14472.n1 vss 0.04219f
C474 a_n132_14472.n2 vss 0.12741f
C475 a_n132_14472.t13 vss 0.09226f
C476 a_n132_14472.t14 vss 0.09907f
C477 a_n132_14472.n3 vss 0.04219f
C478 a_n132_14472.n4 vss 0.19214f
C479 a_n132_14472.t15 vss 0.09226f
C480 a_n132_14472.t16 vss 0.09907f
C481 a_n132_14472.n5 vss 0.04219f
C482 a_n132_14472.n6 vss 0.19214f
C483 a_n132_14472.t17 vss 0.09226f
C484 a_n132_14472.t18 vss 0.09907f
C485 a_n132_14472.n7 vss 0.04219f
C486 a_n132_14472.n8 vss 0.29186f
C487 a_n132_14472.t1 vss 0.09907f
C488 a_n132_14472.t2 vss 0.09226f
C489 a_n132_14472.n9 vss 0.05197f
C490 a_n132_14472.t3 vss 0.09226f
C491 a_n132_14472.t4 vss 0.09907f
C492 a_n132_14472.n10 vss 0.04219f
C493 a_n132_14472.n11 vss 0.28452f
C494 a_n132_14472.t5 vss 0.09226f
C495 a_n132_14472.t6 vss 0.09907f
C496 a_n132_14472.n12 vss 0.04219f
C497 a_n132_14472.n13 vss 0.19214f
C498 a_n132_14472.t7 vss 0.09226f
C499 a_n132_14472.t8 vss 0.09907f
C500 a_n132_14472.n14 vss 0.04219f
C501 a_n132_14472.n15 vss 0.19214f
C502 a_n132_14472.t9 vss 0.09226f
C503 a_n132_14472.t10 vss 0.09907f
C504 a_n132_14472.n16 vss 0.04219f
C505 a_n132_14472.n17 vss 0.12904f
C506 a_n132_14472.n18 vss 0.16398f
C507 a_n132_14472.t0 vss 5.92499f
C508 a_n132_14472.t31 vss 0.08873f
C509 a_n132_14472.t32 vss 0.08873f
C510 a_n132_14472.n19 vss 0.02379f
C511 a_n132_14472.n20 vss 0.11243f
C512 a_n132_14472.t33 vss 0.08873f
C513 a_n132_14472.t34 vss 0.08873f
C514 a_n132_14472.n21 vss 0.02379f
C515 a_n132_14472.n22 vss 0.16602f
C516 a_n132_14472.t35 vss 0.08873f
C517 a_n132_14472.t36 vss 0.08873f
C518 a_n132_14472.n23 vss 0.02379f
C519 a_n132_14472.n24 vss 0.16602f
C520 a_n132_14472.t37 vss 0.08873f
C521 a_n132_14472.t38 vss 0.08873f
C522 a_n132_14472.n25 vss 0.02379f
C523 a_n132_14472.n26 vss 0.25532f
C524 a_n132_14472.t39 vss 0.08873f
C525 a_n132_14472.t40 vss 0.08955f
C526 a_n132_14472.n27 vss 0.02821f
C527 a_n132_14472.t21 vss 0.08873f
C528 a_n132_14472.t22 vss 0.08873f
C529 a_n132_14472.n28 vss 0.02824f
C530 a_n132_14472.t23 vss 0.08873f
C531 a_n132_14472.t24 vss 0.08873f
C532 a_n132_14472.n29 vss 0.02379f
C533 a_n132_14472.n30 vss 0.25592f
C534 a_n132_14472.t25 vss 0.08873f
C535 a_n132_14472.t26 vss 0.08873f
C536 a_n132_14472.n31 vss 0.02379f
C537 a_n132_14472.n32 vss 0.16602f
C538 a_n132_14472.t27 vss 0.08873f
C539 a_n132_14472.t28 vss 0.08873f
C540 a_n132_14472.n33 vss 0.02379f
C541 a_n132_14472.n34 vss 0.16602f
C542 a_n132_14472.t29 vss 0.08873f
C543 a_n132_14472.t30 vss 0.08873f
C544 a_n132_14472.n35 vss 0.02379f
C545 a_n132_14472.n36 vss 0.10667f
C546 a_n132_14472.n37 vss 5.84498f
C547 a_n132_14472.t19 vss 0.09226f
C548 a_n132_12072.t20 vss 0.09972f
C549 a_n132_12072.n0 vss 0.05296f
C550 a_n132_12072.t11 vss 0.09233f
C551 a_n132_12072.t12 vss 0.09915f
C552 a_n132_12072.n1 vss 0.04233f
C553 a_n132_12072.n2 vss 0.12786f
C554 a_n132_12072.t13 vss 0.09233f
C555 a_n132_12072.t14 vss 0.09915f
C556 a_n132_12072.n3 vss 0.04233f
C557 a_n132_12072.n4 vss 0.19282f
C558 a_n132_12072.t15 vss 0.09233f
C559 a_n132_12072.t16 vss 0.09915f
C560 a_n132_12072.n5 vss 0.04233f
C561 a_n132_12072.n6 vss 0.19282f
C562 a_n132_12072.t17 vss 0.09233f
C563 a_n132_12072.t18 vss 0.09915f
C564 a_n132_12072.n7 vss 0.04233f
C565 a_n132_12072.n8 vss 0.29289f
C566 a_n132_12072.t1 vss 0.09915f
C567 a_n132_12072.t2 vss 0.09233f
C568 a_n132_12072.n9 vss 0.05216f
C569 a_n132_12072.t3 vss 0.09233f
C570 a_n132_12072.t4 vss 0.09915f
C571 a_n132_12072.n10 vss 0.04233f
C572 a_n132_12072.n11 vss 0.28552f
C573 a_n132_12072.t5 vss 0.09233f
C574 a_n132_12072.t6 vss 0.09915f
C575 a_n132_12072.n12 vss 0.04233f
C576 a_n132_12072.n13 vss 0.19282f
C577 a_n132_12072.t7 vss 0.09233f
C578 a_n132_12072.t8 vss 0.09915f
C579 a_n132_12072.n14 vss 0.04233f
C580 a_n132_12072.n15 vss 0.19282f
C581 a_n132_12072.t9 vss 0.09233f
C582 a_n132_12072.t10 vss 0.09915f
C583 a_n132_12072.n16 vss 0.04233f
C584 a_n132_12072.n17 vss 0.12949f
C585 a_n132_12072.n18 vss 0.1643f
C586 a_n132_12072.t0 vss 5.73299f
C587 a_n132_12072.t39 vss 0.08878f
C588 a_n132_12072.t40 vss 0.08959f
C589 a_n132_12072.n19 vss 0.02831f
C590 a_n132_12072.t37 vss 0.08878f
C591 a_n132_12072.t38 vss 0.08878f
C592 a_n132_12072.n20 vss 0.02387f
C593 a_n132_12072.n21 vss 0.25622f
C594 a_n132_12072.t35 vss 0.08878f
C595 a_n132_12072.t36 vss 0.08878f
C596 a_n132_12072.n22 vss 0.02387f
C597 a_n132_12072.n23 vss 0.16661f
C598 a_n132_12072.t33 vss 0.08878f
C599 a_n132_12072.t34 vss 0.08878f
C600 a_n132_12072.n24 vss 0.02387f
C601 a_n132_12072.n25 vss 0.16661f
C602 a_n132_12072.t31 vss 0.08878f
C603 a_n132_12072.t32 vss 0.08878f
C604 a_n132_12072.n26 vss 0.02387f
C605 a_n132_12072.n27 vss 0.11282f
C606 a_n132_12072.t29 vss 0.08878f
C607 a_n132_12072.t30 vss 0.08878f
C608 a_n132_12072.n28 vss 0.02387f
C609 a_n132_12072.n29 vss 0.10705f
C610 a_n132_12072.t27 vss 0.08878f
C611 a_n132_12072.t28 vss 0.08878f
C612 a_n132_12072.n30 vss 0.02387f
C613 a_n132_12072.n31 vss 0.16661f
C614 a_n132_12072.t25 vss 0.08878f
C615 a_n132_12072.t26 vss 0.08878f
C616 a_n132_12072.n32 vss 0.02387f
C617 a_n132_12072.n33 vss 0.16661f
C618 a_n132_12072.t23 vss 0.08878f
C619 a_n132_12072.t24 vss 0.08878f
C620 a_n132_12072.n34 vss 0.02387f
C621 a_n132_12072.n35 vss 0.25682f
C622 a_n132_12072.t21 vss 0.08878f
C623 a_n132_12072.t22 vss 0.08878f
C624 a_n132_12072.n36 vss 0.02834f
C625 a_n132_12072.n37 vss 5.6398f
C626 a_n132_12072.t19 vss 0.09233f
C627 a_n132_9672.t20 vss 0.09372f
C628 a_n132_9672.n0 vss 0.04542f
C629 a_n132_9672.t11 vss 0.08732f
C630 a_n132_9672.t12 vss 0.09317f
C631 a_n132_9672.n1 vss 0.03631f
C632 a_n132_9672.n2 vss 0.10966f
C633 a_n132_9672.t13 vss 0.08732f
C634 a_n132_9672.t14 vss 0.09317f
C635 a_n132_9672.n3 vss 0.03631f
C636 a_n132_9672.n4 vss 0.16538f
C637 a_n132_9672.t15 vss 0.08732f
C638 a_n132_9672.t16 vss 0.09317f
C639 a_n132_9672.n5 vss 0.03631f
C640 a_n132_9672.n6 vss 0.16538f
C641 a_n132_9672.t17 vss 0.08732f
C642 a_n132_9672.t18 vss 0.09317f
C643 a_n132_9672.n7 vss 0.03631f
C644 a_n132_9672.n8 vss 0.2512f
C645 a_n132_9672.t1 vss 0.09317f
C646 a_n132_9672.t2 vss 0.08732f
C647 a_n132_9672.n9 vss 0.04473f
C648 a_n132_9672.t3 vss 0.08732f
C649 a_n132_9672.t4 vss 0.09317f
C650 a_n132_9672.n10 vss 0.03631f
C651 a_n132_9672.n11 vss 0.24489f
C652 a_n132_9672.t5 vss 0.08732f
C653 a_n132_9672.t6 vss 0.09317f
C654 a_n132_9672.n12 vss 0.03631f
C655 a_n132_9672.n13 vss 0.16538f
C656 a_n132_9672.t7 vss 0.08732f
C657 a_n132_9672.t8 vss 0.09317f
C658 a_n132_9672.n14 vss 0.03631f
C659 a_n132_9672.n15 vss 0.16538f
C660 a_n132_9672.t9 vss 0.08732f
C661 a_n132_9672.t10 vss 0.09317f
C662 a_n132_9672.n16 vss 0.03631f
C663 a_n132_9672.n17 vss 0.11106f
C664 a_n132_9672.n18 vss 0.14113f
C665 a_n132_9672.t0 vss 4.79716f
C666 a_n132_9672.t31 vss 0.08452f
C667 a_n132_9672.t32 vss 0.08452f
C668 a_n132_9672.n19 vss 0.02047f
C669 a_n132_9672.n20 vss 0.09676f
C670 a_n132_9672.t33 vss 0.08452f
C671 a_n132_9672.t34 vss 0.08452f
C672 a_n132_9672.n21 vss 0.02047f
C673 a_n132_9672.n22 vss 0.1429f
C674 a_n132_9672.t35 vss 0.08452f
C675 a_n132_9672.t36 vss 0.08452f
C676 a_n132_9672.n23 vss 0.02047f
C677 a_n132_9672.n24 vss 0.1429f
C678 a_n132_9672.t37 vss 0.08452f
C679 a_n132_9672.t38 vss 0.08452f
C680 a_n132_9672.n25 vss 0.02047f
C681 a_n132_9672.n26 vss 0.21975f
C682 a_n132_9672.t39 vss 0.08452f
C683 a_n132_9672.t40 vss 0.08531f
C684 a_n132_9672.n27 vss 0.02428f
C685 a_n132_9672.t21 vss 0.08452f
C686 a_n132_9672.t22 vss 0.08452f
C687 a_n132_9672.n28 vss 0.0243f
C688 a_n132_9672.t23 vss 0.08452f
C689 a_n132_9672.t24 vss 0.08452f
C690 a_n132_9672.n29 vss 0.02047f
C691 a_n132_9672.n30 vss 0.22027f
C692 a_n132_9672.t25 vss 0.08452f
C693 a_n132_9672.t26 vss 0.08452f
C694 a_n132_9672.n31 vss 0.02047f
C695 a_n132_9672.n32 vss 0.1429f
C696 a_n132_9672.t27 vss 0.08452f
C697 a_n132_9672.t28 vss 0.08452f
C698 a_n132_9672.n33 vss 0.02047f
C699 a_n132_9672.n34 vss 0.1429f
C700 a_n132_9672.t29 vss 0.08452f
C701 a_n132_9672.t30 vss 0.08452f
C702 a_n132_9672.n35 vss 0.02047f
C703 a_n132_9672.n36 vss 0.09181f
C704 a_n132_9672.n37 vss 4.71259f
C705 a_n132_9672.t19 vss 0.08732f
C706 a_33552_5556.t9 vss 0.10489f
C707 a_33552_5556.n0 vss 0.08057f
C708 a_33552_5556.t0 vss 0.10455f
C709 a_33552_5556.t1 vss 0.09177f
C710 a_33552_5556.n1 vss 0.10052f
C711 a_33552_5556.t2 vss 0.09177f
C712 a_33552_5556.t3 vss 0.10455f
C713 a_33552_5556.n2 vss 0.08002f
C714 a_33552_5556.n3 vss 0.20035f
C715 a_33552_5556.t4 vss 0.09177f
C716 a_33552_5556.t5 vss 0.10455f
C717 a_33552_5556.n4 vss 0.08002f
C718 a_33552_5556.n5 vss 0.13705f
C719 a_33552_5556.t6 vss 0.09177f
C720 a_33552_5556.t7 vss 0.10455f
C721 a_33552_5556.n6 vss 0.08002f
C722 a_33552_5556.n7 vss 0.13428f
C723 a_33552_5556.n8 vss 0.1576f
C724 a_33552_5556.t16 vss 0.08266f
C725 a_33552_5556.t17 vss 0.08266f
C726 a_33552_5556.n9 vss 0.04502f
C727 a_33552_5556.n10 vss 0.12724f
C728 a_33552_5556.t14 vss 0.08266f
C729 a_33552_5556.t15 vss 0.08266f
C730 a_33552_5556.n11 vss 0.04502f
C731 a_33552_5556.n12 vss 0.13242f
C732 a_33552_5556.t12 vss 0.08266f
C733 a_33552_5556.t13 vss 0.08266f
C734 a_33552_5556.n13 vss 0.04502f
C735 a_33552_5556.n14 vss 0.20634f
C736 a_33552_5556.t10 vss 0.08266f
C737 a_33552_5556.t11 vss 0.08266f
C738 a_33552_5556.n15 vss 0.05509f
C739 a_33552_5556.n16 vss 0.12377f
C740 a_33552_5556.n17 vss 0.15234f
C741 a_33552_5556.n18 vss 0.17195f
C742 a_33552_5556.n19 vss 0.17195f
C743 a_33552_5556.n20 vss 0.17195f
C744 a_33552_5556.n21 vss 0.1372f
C745 a_33552_5556.n22 vss 0.17195f
C746 a_33552_5556.n23 vss 0.17195f
C747 a_33552_5556.n24 vss 0.17195f
C748 a_33552_5556.n25 vss 0.58565f
C749 a_33552_5556.n26 vss 0.2363f
C750 a_33552_5556.n27 vss 0.17195f
C751 a_33552_5556.n28 vss 0.17195f
C752 a_33552_5556.n29 vss 0.17195f
C753 a_33552_5556.n30 vss 0.17195f
C754 a_33552_5556.n31 vss 0.17195f
C755 a_33552_5556.n32 vss 0.17195f
C756 a_33552_5556.n33 vss 0.17195f
C757 a_33552_5556.n34 vss 0.17195f
C758 a_33552_5556.n35 vss 0.17195f
C759 a_33552_5556.n36 vss 0.49883f
C760 a_33552_5556.n37 vss 0.26179f
C761 a_33552_5556.t18 vss 0.07526f
C762 a_33552_5556.t19 vss 0.08342f
C763 a_33552_5556.n38 vss 0.04517f
C764 a_33552_5556.t8 vss 0.09222f
C765 a_33552_5176.t9 vss 0.10965f
C766 a_33552_5176.n0 vss 0.0833f
C767 a_33552_5176.t10 vss 0.08185f
C768 a_33552_5176.t11 vss 0.08185f
C769 a_33552_5176.n1 vss 0.05695f
C770 a_33552_5176.t12 vss 0.08185f
C771 a_33552_5176.t13 vss 0.08185f
C772 a_33552_5176.n2 vss 0.04654f
C773 a_33552_5176.n3 vss 0.21332f
C774 a_33552_5176.t14 vss 0.08185f
C775 a_33552_5176.t15 vss 0.08185f
C776 a_33552_5176.n4 vss 0.04654f
C777 a_33552_5176.n5 vss 0.1369f
C778 a_33552_5176.t16 vss 0.08185f
C779 a_33552_5176.t17 vss 0.08185f
C780 a_33552_5176.n6 vss 0.04654f
C781 a_33552_5176.n7 vss 0.13154f
C782 a_33552_5176.n8 vss 0.12795f
C783 a_33552_5176.t6 vss 0.09251f
C784 a_33552_5176.t7 vss 0.10572f
C785 a_33552_5176.n9 vss 0.08272f
C786 a_33552_5176.n10 vss 0.13882f
C787 a_33552_5176.t4 vss 0.09251f
C788 a_33552_5176.t5 vss 0.10572f
C789 a_33552_5176.n11 vss 0.08272f
C790 a_33552_5176.n12 vss 0.14169f
C791 a_33552_5176.t2 vss 0.09251f
C792 a_33552_5176.t3 vss 0.10572f
C793 a_33552_5176.n13 vss 0.08272f
C794 a_33552_5176.n14 vss 0.20713f
C795 a_33552_5176.t0 vss 0.10779f
C796 a_33552_5176.t1 vss 0.09251f
C797 a_33552_5176.n15 vss 0.10392f
C798 a_33552_5176.n16 vss 0.16293f
C799 a_33552_5176.n17 vss 0.15749f
C800 a_33552_5176.n18 vss 0.17777f
C801 a_33552_5176.n19 vss 0.17777f
C802 a_33552_5176.n20 vss 0.17777f
C803 a_33552_5176.n21 vss 0.14184f
C804 a_33552_5176.n22 vss 0.17777f
C805 a_33552_5176.n23 vss 0.17777f
C806 a_33552_5176.n24 vss 0.17777f
C807 a_33552_5176.n25 vss 0.60546f
C808 a_33552_5176.n26 vss 0.2443f
C809 a_33552_5176.n27 vss 0.17777f
C810 a_33552_5176.n28 vss 0.17777f
C811 a_33552_5176.n29 vss 0.17777f
C812 a_33552_5176.n30 vss 0.17777f
C813 a_33552_5176.n31 vss 0.17777f
C814 a_33552_5176.n32 vss 0.17777f
C815 a_33552_5176.n33 vss 0.17777f
C816 a_33552_5176.n34 vss 0.17777f
C817 a_33552_5176.n35 vss 0.17777f
C818 a_33552_5176.n36 vss 0.5157f
C819 a_33552_5176.n37 vss 0.27065f
C820 a_33552_5176.t18 vss 0.07889f
C821 a_33552_5176.t19 vss 0.08749f
C822 a_33552_5176.n38 vss 0.0467f
C823 a_33552_5176.t8 vss 0.09654f
C824 a_33552_3988.t9 vss 0.10964f
C825 a_33552_3988.n0 vss 0.0833f
C826 a_33552_3988.t0 vss 0.10928f
C827 a_33552_3988.t1 vss 0.09607f
C828 a_33552_3988.n1 vss 0.10392f
C829 a_33552_3988.t2 vss 0.09607f
C830 a_33552_3988.t3 vss 0.10928f
C831 a_33552_3988.n2 vss 0.08272f
C832 a_33552_3988.n3 vss 0.20713f
C833 a_33552_3988.t4 vss 0.09607f
C834 a_33552_3988.t5 vss 0.10928f
C835 a_33552_3988.n4 vss 0.08272f
C836 a_33552_3988.n5 vss 0.14169f
C837 a_33552_3988.t6 vss 0.09607f
C838 a_33552_3988.t7 vss 0.10928f
C839 a_33552_3988.n6 vss 0.08272f
C840 a_33552_3988.n7 vss 0.13882f
C841 a_33552_3988.n8 vss 0.16293f
C842 a_33552_3988.t16 vss 0.08669f
C843 a_33552_3988.t17 vss 0.08669f
C844 a_33552_3988.n9 vss 0.04654f
C845 a_33552_3988.n10 vss 0.13154f
C846 a_33552_3988.t14 vss 0.08669f
C847 a_33552_3988.t15 vss 0.08669f
C848 a_33552_3988.n11 vss 0.04654f
C849 a_33552_3988.n12 vss 0.1369f
C850 a_33552_3988.t12 vss 0.08669f
C851 a_33552_3988.t13 vss 0.08669f
C852 a_33552_3988.n13 vss 0.04654f
C853 a_33552_3988.n14 vss 0.21332f
C854 a_33552_3988.t10 vss 0.08669f
C855 a_33552_3988.t11 vss 0.08669f
C856 a_33552_3988.n15 vss 0.05695f
C857 a_33552_3988.n16 vss 0.12795f
C858 a_33552_3988.n17 vss 0.15749f
C859 a_33552_3988.n18 vss 0.17777f
C860 a_33552_3988.n19 vss 0.17777f
C861 a_33552_3988.n20 vss 0.17777f
C862 a_33552_3988.n21 vss 0.14184f
C863 a_33552_3988.n22 vss 0.17777f
C864 a_33552_3988.n23 vss 0.17777f
C865 a_33552_3988.n24 vss 0.17777f
C866 a_33552_3988.n25 vss 0.60546f
C867 a_33552_3988.n26 vss 0.2443f
C868 a_33552_3988.n27 vss 0.17777f
C869 a_33552_3988.n28 vss 0.17777f
C870 a_33552_3988.n29 vss 0.17777f
C871 a_33552_3988.n30 vss 0.17777f
C872 a_33552_3988.n31 vss 0.17777f
C873 a_33552_3988.n32 vss 0.17777f
C874 a_33552_3988.n33 vss 0.17777f
C875 a_33552_3988.n34 vss 0.17777f
C876 a_33552_3988.n35 vss 0.17777f
C877 a_33552_3988.n36 vss 0.5157f
C878 a_33552_3988.n37 vss 0.27065f
C879 a_33552_3988.t18 vss 0.07889f
C880 a_33552_3988.t19 vss 0.08749f
C881 a_33552_3988.n38 vss 0.0467f
C882 a_33552_3988.t8 vss 0.09654f
C883 a_33552_3608.t9 vss 0.10964f
C884 a_33552_3608.n0 vss 0.0833f
C885 a_33552_3608.t10 vss 0.08185f
C886 a_33552_3608.t11 vss 0.08185f
C887 a_33552_3608.n1 vss 0.05695f
C888 a_33552_3608.t12 vss 0.08185f
C889 a_33552_3608.t13 vss 0.08185f
C890 a_33552_3608.n2 vss 0.04654f
C891 a_33552_3608.n3 vss 0.21332f
C892 a_33552_3608.t14 vss 0.08185f
C893 a_33552_3608.t15 vss 0.08185f
C894 a_33552_3608.n4 vss 0.04654f
C895 a_33552_3608.n5 vss 0.1369f
C896 a_33552_3608.t16 vss 0.08185f
C897 a_33552_3608.t17 vss 0.08185f
C898 a_33552_3608.n6 vss 0.04654f
C899 a_33552_3608.n7 vss 0.13154f
C900 a_33552_3608.n8 vss 0.12795f
C901 a_33552_3608.t6 vss 0.0925f
C902 a_33552_3608.t7 vss 0.10572f
C903 a_33552_3608.n9 vss 0.08272f
C904 a_33552_3608.n10 vss 0.13882f
C905 a_33552_3608.t4 vss 0.0925f
C906 a_33552_3608.t5 vss 0.10572f
C907 a_33552_3608.n11 vss 0.08272f
C908 a_33552_3608.n12 vss 0.14169f
C909 a_33552_3608.t2 vss 0.0925f
C910 a_33552_3608.t3 vss 0.10572f
C911 a_33552_3608.n13 vss 0.08272f
C912 a_33552_3608.n14 vss 0.20713f
C913 a_33552_3608.t0 vss 0.10778f
C914 a_33552_3608.t1 vss 0.0925f
C915 a_33552_3608.n15 vss 0.10392f
C916 a_33552_3608.n16 vss 0.16293f
C917 a_33552_3608.n17 vss 0.15749f
C918 a_33552_3608.n18 vss 0.17777f
C919 a_33552_3608.n19 vss 0.17777f
C920 a_33552_3608.n20 vss 0.17777f
C921 a_33552_3608.n21 vss 0.14184f
C922 a_33552_3608.n22 vss 0.17777f
C923 a_33552_3608.n23 vss 0.17777f
C924 a_33552_3608.n24 vss 0.17777f
C925 a_33552_3608.n25 vss 0.60546f
C926 a_33552_3608.n26 vss 0.2443f
C927 a_33552_3608.n27 vss 0.17777f
C928 a_33552_3608.n28 vss 0.17777f
C929 a_33552_3608.n29 vss 0.17777f
C930 a_33552_3608.n30 vss 0.17777f
C931 a_33552_3608.n31 vss 0.17777f
C932 a_33552_3608.n32 vss 0.17777f
C933 a_33552_3608.n33 vss 0.17777f
C934 a_33552_3608.n34 vss 0.17777f
C935 a_33552_3608.n35 vss 0.17777f
C936 a_33552_3608.n36 vss 0.5157f
C937 a_33552_3608.n37 vss 0.27065f
C938 a_33552_3608.t18 vss 0.07889f
C939 a_33552_3608.t19 vss 0.08749f
C940 a_33552_3608.n38 vss 0.0467f
C941 a_33552_3608.t8 vss 0.09654f
C942 a_33552_2420.t9 vss 0.10964f
C943 a_33552_2420.n0 vss 0.0833f
C944 a_33552_2420.t0 vss 0.10928f
C945 a_33552_2420.t1 vss 0.09607f
C946 a_33552_2420.n1 vss 0.10392f
C947 a_33552_2420.t2 vss 0.09607f
C948 a_33552_2420.t3 vss 0.10928f
C949 a_33552_2420.n2 vss 0.08272f
C950 a_33552_2420.n3 vss 0.20713f
C951 a_33552_2420.t4 vss 0.09607f
C952 a_33552_2420.t5 vss 0.10928f
C953 a_33552_2420.n4 vss 0.08272f
C954 a_33552_2420.n5 vss 0.14169f
C955 a_33552_2420.t6 vss 0.09607f
C956 a_33552_2420.t7 vss 0.10928f
C957 a_33552_2420.n6 vss 0.08272f
C958 a_33552_2420.n7 vss 0.13882f
C959 a_33552_2420.n8 vss 0.16293f
C960 a_33552_2420.t16 vss 0.08669f
C961 a_33552_2420.t17 vss 0.08669f
C962 a_33552_2420.n9 vss 0.04654f
C963 a_33552_2420.n10 vss 0.13154f
C964 a_33552_2420.t14 vss 0.08669f
C965 a_33552_2420.t15 vss 0.08669f
C966 a_33552_2420.n11 vss 0.04654f
C967 a_33552_2420.n12 vss 0.1369f
C968 a_33552_2420.t12 vss 0.08669f
C969 a_33552_2420.t13 vss 0.08669f
C970 a_33552_2420.n13 vss 0.04654f
C971 a_33552_2420.n14 vss 0.21332f
C972 a_33552_2420.t10 vss 0.08669f
C973 a_33552_2420.t11 vss 0.08669f
C974 a_33552_2420.n15 vss 0.05695f
C975 a_33552_2420.n16 vss 0.12795f
C976 a_33552_2420.n17 vss 0.15749f
C977 a_33552_2420.n18 vss 0.17777f
C978 a_33552_2420.n19 vss 0.17777f
C979 a_33552_2420.n20 vss 0.17777f
C980 a_33552_2420.n21 vss 0.14184f
C981 a_33552_2420.n22 vss 0.17777f
C982 a_33552_2420.n23 vss 0.17777f
C983 a_33552_2420.n24 vss 0.17777f
C984 a_33552_2420.n25 vss 0.60546f
C985 a_33552_2420.n26 vss 0.2443f
C986 a_33552_2420.n27 vss 0.17777f
C987 a_33552_2420.n28 vss 0.17777f
C988 a_33552_2420.n29 vss 0.17777f
C989 a_33552_2420.n30 vss 0.17777f
C990 a_33552_2420.n31 vss 0.17777f
C991 a_33552_2420.n32 vss 0.17777f
C992 a_33552_2420.n33 vss 0.17777f
C993 a_33552_2420.n34 vss 0.17777f
C994 a_33552_2420.n35 vss 0.17777f
C995 a_33552_2420.n36 vss 0.5157f
C996 a_33552_2420.n37 vss 0.27065f
C997 a_33552_2420.t18 vss 0.07889f
C998 a_33552_2420.t19 vss 0.08749f
C999 a_33552_2420.n38 vss 0.0467f
C1000 a_33552_2420.t8 vss 0.09654f
C1001 a_33552_2040.t9 vss 0.10964f
C1002 a_33552_2040.n0 vss 0.0833f
C1003 a_33552_2040.t10 vss 0.08185f
C1004 a_33552_2040.t11 vss 0.08185f
C1005 a_33552_2040.n1 vss 0.05695f
C1006 a_33552_2040.t12 vss 0.08185f
C1007 a_33552_2040.t13 vss 0.08185f
C1008 a_33552_2040.n2 vss 0.04654f
C1009 a_33552_2040.n3 vss 0.21332f
C1010 a_33552_2040.t14 vss 0.08185f
C1011 a_33552_2040.t15 vss 0.08185f
C1012 a_33552_2040.n4 vss 0.04654f
C1013 a_33552_2040.n5 vss 0.1369f
C1014 a_33552_2040.t16 vss 0.08185f
C1015 a_33552_2040.t17 vss 0.08185f
C1016 a_33552_2040.n6 vss 0.04654f
C1017 a_33552_2040.n7 vss 0.13154f
C1018 a_33552_2040.n8 vss 0.12795f
C1019 a_33552_2040.t6 vss 0.0925f
C1020 a_33552_2040.t7 vss 0.10572f
C1021 a_33552_2040.n9 vss 0.08272f
C1022 a_33552_2040.n10 vss 0.13882f
C1023 a_33552_2040.t4 vss 0.0925f
C1024 a_33552_2040.t5 vss 0.10572f
C1025 a_33552_2040.n11 vss 0.08272f
C1026 a_33552_2040.n12 vss 0.14169f
C1027 a_33552_2040.t2 vss 0.0925f
C1028 a_33552_2040.t3 vss 0.10572f
C1029 a_33552_2040.n13 vss 0.08272f
C1030 a_33552_2040.n14 vss 0.20713f
C1031 a_33552_2040.t0 vss 0.10778f
C1032 a_33552_2040.t1 vss 0.0925f
C1033 a_33552_2040.n15 vss 0.10392f
C1034 a_33552_2040.n16 vss 0.16293f
C1035 a_33552_2040.n17 vss 0.15749f
C1036 a_33552_2040.n18 vss 0.17777f
C1037 a_33552_2040.n19 vss 0.17777f
C1038 a_33552_2040.n20 vss 0.17777f
C1039 a_33552_2040.n21 vss 0.14184f
C1040 a_33552_2040.n22 vss 0.17777f
C1041 a_33552_2040.n23 vss 0.17777f
C1042 a_33552_2040.n24 vss 0.17777f
C1043 a_33552_2040.n25 vss 0.60546f
C1044 a_33552_2040.n26 vss 0.2443f
C1045 a_33552_2040.n27 vss 0.17777f
C1046 a_33552_2040.n28 vss 0.17777f
C1047 a_33552_2040.n29 vss 0.17777f
C1048 a_33552_2040.n30 vss 0.17777f
C1049 a_33552_2040.n31 vss 0.17777f
C1050 a_33552_2040.n32 vss 0.17777f
C1051 a_33552_2040.n33 vss 0.17777f
C1052 a_33552_2040.n34 vss 0.17777f
C1053 a_33552_2040.n35 vss 0.17777f
C1054 a_33552_2040.n36 vss 0.5157f
C1055 a_33552_2040.n37 vss 0.27065f
C1056 a_33552_2040.t18 vss 0.07889f
C1057 a_33552_2040.t19 vss 0.08749f
C1058 a_33552_2040.n38 vss 0.0467f
C1059 a_33552_2040.t8 vss 0.09654f
C1060 a_33552_852.t9 vss 0.10964f
C1061 a_33552_852.n0 vss 0.0833f
C1062 a_33552_852.t0 vss 0.10928f
C1063 a_33552_852.t1 vss 0.09607f
C1064 a_33552_852.n1 vss 0.10392f
C1065 a_33552_852.t2 vss 0.09607f
C1066 a_33552_852.t3 vss 0.10928f
C1067 a_33552_852.n2 vss 0.08272f
C1068 a_33552_852.n3 vss 0.20713f
C1069 a_33552_852.t4 vss 0.09607f
C1070 a_33552_852.t5 vss 0.10928f
C1071 a_33552_852.n4 vss 0.08272f
C1072 a_33552_852.n5 vss 0.14169f
C1073 a_33552_852.t6 vss 0.09607f
C1074 a_33552_852.t7 vss 0.10928f
C1075 a_33552_852.n6 vss 0.08272f
C1076 a_33552_852.n7 vss 0.13882f
C1077 a_33552_852.n8 vss 0.16293f
C1078 a_33552_852.t16 vss 0.08669f
C1079 a_33552_852.t17 vss 0.08669f
C1080 a_33552_852.n9 vss 0.04654f
C1081 a_33552_852.n10 vss 0.13154f
C1082 a_33552_852.t14 vss 0.08669f
C1083 a_33552_852.t15 vss 0.08669f
C1084 a_33552_852.n11 vss 0.04654f
C1085 a_33552_852.n12 vss 0.1369f
C1086 a_33552_852.t12 vss 0.08669f
C1087 a_33552_852.t13 vss 0.08669f
C1088 a_33552_852.n13 vss 0.04654f
C1089 a_33552_852.n14 vss 0.21332f
C1090 a_33552_852.t10 vss 0.08669f
C1091 a_33552_852.t11 vss 0.08669f
C1092 a_33552_852.n15 vss 0.05695f
C1093 a_33552_852.n16 vss 0.12795f
C1094 a_33552_852.n17 vss 0.15749f
C1095 a_33552_852.n18 vss 0.17777f
C1096 a_33552_852.n19 vss 0.17777f
C1097 a_33552_852.n20 vss 0.17777f
C1098 a_33552_852.n21 vss 0.14184f
C1099 a_33552_852.n22 vss 0.17777f
C1100 a_33552_852.n23 vss 0.17777f
C1101 a_33552_852.n24 vss 0.17777f
C1102 a_33552_852.n25 vss 0.60546f
C1103 a_33552_852.n26 vss 0.2443f
C1104 a_33552_852.n27 vss 0.17777f
C1105 a_33552_852.n28 vss 0.17777f
C1106 a_33552_852.n29 vss 0.17777f
C1107 a_33552_852.n30 vss 0.17777f
C1108 a_33552_852.n31 vss 0.17777f
C1109 a_33552_852.n32 vss 0.17777f
C1110 a_33552_852.n33 vss 0.17777f
C1111 a_33552_852.n34 vss 0.17777f
C1112 a_33552_852.n35 vss 0.17777f
C1113 a_33552_852.n36 vss 0.5157f
C1114 a_33552_852.n37 vss 0.27065f
C1115 a_33552_852.t18 vss 0.07889f
C1116 a_33552_852.t19 vss 0.08749f
C1117 a_33552_852.n38 vss 0.0467f
C1118 a_33552_852.t8 vss 0.09654f
C1119 a_33552_472.t9 vss 0.10437f
C1120 a_33552_472.n0 vss 0.08053f
C1121 a_33552_472.t10 vss 0.07759f
C1122 a_33552_472.t11 vss 0.07759f
C1123 a_33552_472.n1 vss 0.05505f
C1124 a_33552_472.t12 vss 0.07759f
C1125 a_33552_472.t13 vss 0.07759f
C1126 a_33552_472.n2 vss 0.04499f
C1127 a_33552_472.n3 vss 0.20622f
C1128 a_33552_472.t14 vss 0.07759f
C1129 a_33552_472.t15 vss 0.07759f
C1130 a_33552_472.n4 vss 0.04499f
C1131 a_33552_472.n5 vss 0.13234f
C1132 a_33552_472.t16 vss 0.07759f
C1133 a_33552_472.t17 vss 0.07759f
C1134 a_33552_472.n6 vss 0.04499f
C1135 a_33552_472.n7 vss 0.12716f
C1136 a_33552_472.n8 vss 0.12369f
C1137 a_33552_472.t6 vss 0.08791f
C1138 a_33552_472.t7 vss 0.10068f
C1139 a_33552_472.n9 vss 0.07997f
C1140 a_33552_472.n10 vss 0.1342f
C1141 a_33552_472.t4 vss 0.08791f
C1142 a_33552_472.t5 vss 0.10068f
C1143 a_33552_472.n11 vss 0.07997f
C1144 a_33552_472.n12 vss 0.13697f
C1145 a_33552_472.t2 vss 0.08791f
C1146 a_33552_472.t3 vss 0.10068f
C1147 a_33552_472.n13 vss 0.07997f
C1148 a_33552_472.n14 vss 0.20023f
C1149 a_33552_472.t0 vss 0.10262f
C1150 a_33552_472.t1 vss 0.08791f
C1151 a_33552_472.n15 vss 0.10046f
C1152 a_33552_472.n16 vss 0.15751f
C1153 a_33552_472.n17 vss 0.15225f
C1154 a_33552_472.n18 vss 0.17185f
C1155 a_33552_472.n19 vss 0.17185f
C1156 a_33552_472.n20 vss 0.17185f
C1157 a_33552_472.n21 vss 0.13712f
C1158 a_33552_472.n22 vss 0.17185f
C1159 a_33552_472.n23 vss 0.17185f
C1160 a_33552_472.n24 vss 0.17185f
C1161 a_33552_472.n25 vss 0.5853f
C1162 a_33552_472.n26 vss 0.23616f
C1163 a_33552_472.n27 vss 0.17185f
C1164 a_33552_472.n28 vss 0.17185f
C1165 a_33552_472.n29 vss 0.17185f
C1166 a_33552_472.n30 vss 0.17185f
C1167 a_33552_472.n31 vss 0.17185f
C1168 a_33552_472.n32 vss 0.17185f
C1169 a_33552_472.n33 vss 0.17185f
C1170 a_33552_472.n34 vss 0.17185f
C1171 a_33552_472.n35 vss 0.17185f
C1172 a_33552_472.n36 vss 0.49854f
C1173 a_33552_472.n37 vss 0.26164f
C1174 a_33552_472.t18 vss 0.07481f
C1175 a_33552_472.t19 vss 0.0829f
C1176 a_33552_472.n38 vss 0.04515f
C1177 a_33552_472.t8 vss 0.09171f
C1178 vss.t327 vss 0.07507f
C1179 vss.t118 vss 0.07429f
C1180 vss.t329 vss 0.07429f
C1181 vss.t190 vss 0.07429f
C1182 vss.t120 vss 0.07429f
C1183 vss.t288 vss 0.07429f
C1184 vss.t192 vss 0.07429f
C1185 vss.t272 vss 0.07429f
C1186 vss.t290 vss 0.07429f
C1187 vss.t323 vss 0.07429f
C1188 vss.t274 vss 0.07429f
C1189 vss.t114 vss 0.07429f
C1190 vss.t325 vss 0.07429f
C1191 vss.t38 vss 0.07429f
C1192 vss.t116 vss 0.07429f
C1193 vss.t19 vss 0.07429f
C1194 vss.t40 vss 0.07429f
C1195 vss.t60 vss 0.07429f
C1196 vss.t21 vss 0.07429f
C1197 vss.t363 vss 0.06057f
C1198 vss.t62 vss 0.07429f
C1199 vss.t361 vss 0.05527f
C1200 vss.t355 vss 0.05249f
C1201 vss.t357 vss 0.05527f
C1202 vss.t359 vss 0.05527f
C1203 vss.t351 vss 0.05527f
C1204 vss.t353 vss 0.05527f
C1205 vss.t349 vss 0.05527f
C1206 vss.t345 vss 0.05527f
C1207 vss.t347 vss 0.05527f
C1208 vss.t372 vss 0.06033f
C1209 vss.t374 vss 0.06033f
C1210 vss.t376 vss 0.06033f
C1211 vss.t378 vss 0.06033f
C1212 vss.t380 vss 0.06033f
C1213 vss.t382 vss 0.06033f
C1214 vss.t384 vss 0.06033f
C1215 vss.t386 vss 0.06033f
C1216 vss.t388 vss 0.05293f
C1217 vss.t390 vss 0.06108f
C1218 vss.t236 vss 0.07433f
C1219 vss.t234 vss 0.07433f
C1220 vss.t232 vss 0.07433f
C1221 vss.t226 vss 0.07433f
C1222 vss.t224 vss 0.07433f
C1223 vss.t240 vss 0.07433f
C1224 vss.t238 vss 0.07433f
C1225 vss.t282 vss 0.07433f
C1226 vss.t280 vss 0.07433f
C1227 vss.t230 vss 0.07433f
C1228 vss.t228 vss 0.07433f
C1229 vss.t286 vss 0.07433f
C1230 vss.t284 vss 0.07433f
C1231 vss.t367 vss 0.07433f
C1232 vss.t365 vss 0.07433f
C1233 vss.t166 vss 0.07433f
C1234 vss.t164 vss 0.07433f
C1235 vss.t132 vss 0.07433f
C1236 vss.t130 vss 0.07433f
C1237 vss.t392 vss 0.07512f
C1238 vss.t368 vss 0.07766f
C1239 vss.t264 vss 0.07766f
C1240 vss.t124 vss 0.07684f
C1241 vss.t122 vss 0.07684f
C1242 vss.t270 vss 0.07684f
C1243 vss.t269 vss 0.07684f
C1244 vss.t52 vss 0.07684f
C1245 vss.t50 vss 0.07684f
C1246 vss.t278 vss 0.07684f
C1247 vss.t277 vss 0.07684f
C1248 vss.t31 vss 0.07684f
C1249 vss.t29 vss 0.07684f
C1250 vss.t306 vss 0.07684f
C1251 vss.t305 vss 0.07684f
C1252 vss.t68 vss 0.07684f
C1253 vss.t66 vss 0.07684f
C1254 vss.t158 vss 0.07684f
C1255 vss.t157 vss 0.07684f
C1256 vss.t148 vss 0.07684f
C1257 vss.t146 vss 0.07684f
C1258 vss.t216 vss 0.07684f
C1259 vss.t215 vss 0.07684f
C1260 vss.t154 vss 0.07684f
C1261 vss.t152 vss 0.07684f
C1262 vss.t242 vss 0.07684f
C1263 vss.t241 vss 0.07684f
C1264 vss.t141 vss 0.07684f
C1265 vss.t139 vss 0.07684f
C1266 vss.t276 vss 0.07684f
C1267 vss.t275 vss 0.07684f
C1268 vss.t333 vss 0.07684f
C1269 vss.t331 vss 0.07684f
C1270 vss.t370 vss 0.07684f
C1271 vss.t369 vss 0.07684f
C1272 vss.t311 vss 0.07684f
C1273 vss.t310 vss 0.07684f
C1274 vss.t128 vss 0.07684f
C1275 vss.t126 vss 0.07684f
C1276 vss.t304 vss 0.06439f
C1277 vss.t268 vss 0.07684f
C1278 vss.t186 vss 0.0644f
C1279 vss.t214 vss 0.07684f
C1280 vss.t302 vss 0.0636f
C1281 vss.t303 vss 0.0558f
C1282 vss.t168 vss 0.05876f
C1283 vss.t170 vss 0.0558f
C1284 vss.t300 vss 0.0636f
C1285 vss.t301 vss 0.0636f
C1286 vss.t172 vss 0.05876f
C1287 vss.t174 vss 0.05876f
C1288 vss.t298 vss 0.0636f
C1289 vss.t299 vss 0.0636f
C1290 vss.t182 vss 0.05876f
C1291 vss.t184 vss 0.05876f
C1292 vss.t296 vss 0.0636f
C1293 vss.t297 vss 0.0636f
C1294 vss.t178 vss 0.05876f
C1295 vss.t180 vss 0.05876f
C1296 vss.t295 vss 0.0636f
C1297 vss.t176 vss 0.05876f
C1298 vss.t307 vss 0.07766f
C1299 vss.t102 vss 0.07766f
C1300 vss.t266 vss 0.07684f
C1301 vss.t265 vss 0.07684f
C1302 vss.t100 vss 0.07684f
C1303 vss.t98 vss 0.07684f
C1304 vss.t162 vss 0.07684f
C1305 vss.t161 vss 0.07684f
C1306 vss.t96 vss 0.07684f
C1307 vss.t94 vss 0.07684f
C1308 vss.t188 vss 0.07684f
C1309 vss.t187 vss 0.07684f
C1310 vss.t106 vss 0.07684f
C1311 vss.t104 vss 0.07684f
C1312 vss.t222 vss 0.07684f
C1313 vss.t221 vss 0.07684f
C1314 vss.t92 vss 0.07684f
C1315 vss.t90 vss 0.07684f
C1316 vss.t134 vss 0.07684f
C1317 vss.t133 vss 0.07684f
C1318 vss.t88 vss 0.07684f
C1319 vss.t86 vss 0.07684f
C1320 vss.t220 vss 0.07684f
C1321 vss.t219 vss 0.07684f
C1322 vss.t84 vss 0.07684f
C1323 vss.t82 vss 0.07684f
C1324 vss.t218 vss 0.07684f
C1325 vss.t217 vss 0.07684f
C1326 vss.t76 vss 0.07684f
C1327 vss.t74 vss 0.07684f
C1328 vss.t160 vss 0.07684f
C1329 vss.t159 vss 0.07684f
C1330 vss.t56 vss 0.07684f
C1331 vss.t54 vss 0.07684f
C1332 vss.t44 vss 0.07684f
C1333 vss.t42 vss 0.07684f
C1334 vss.t70 vss 0.07684f
C1335 vss.t69 vss 0.07684f
C1336 vss.t343 vss 0.06439f
C1337 vss.t23 vss 0.07684f
C1338 vss.t262 vss 0.06439f
C1339 vss.t32 vss 0.07684f
C1340 vss.t342 vss 0.0636f
C1341 vss.t336 vss 0.0558f
C1342 vss.t258 vss 0.05875f
C1343 vss.t260 vss 0.0558f
C1344 vss.t337 vss 0.0636f
C1345 vss.t338 vss 0.0636f
C1346 vss.t254 vss 0.05875f
C1347 vss.t256 vss 0.05875f
C1348 vss.t340 vss 0.0636f
C1349 vss.t341 vss 0.0636f
C1350 vss.t250 vss 0.05875f
C1351 vss.t252 vss 0.05875f
C1352 vss.t335 vss 0.0636f
C1353 vss.t339 vss 0.0636f
C1354 vss.t246 vss 0.05875f
C1355 vss.t248 vss 0.05875f
C1356 vss.t334 vss 0.0636f
C1357 vss.t244 vss 0.05875f
C1358 vss.t137 vss 0.07766f
C1359 vss.t112 vss 0.07766f
C1360 vss.t294 vss 0.07684f
C1361 vss.t293 vss 0.07684f
C1362 vss.t80 vss 0.07684f
C1363 vss.t78 vss 0.07684f
C1364 vss.t292 vss 0.07684f
C1365 vss.t291 vss 0.07684f
C1366 vss.t110 vss 0.07684f
C1367 vss.t108 vss 0.07684f
C1368 vss.t48 vss 0.07684f
C1369 vss.t46 vss 0.07684f
C1370 vss.t58 vss 0.07684f
C1371 vss.t57 vss 0.07684f
C1372 vss.t27 vss 0.07684f
C1373 vss.t25 vss 0.07684f
C1374 vss.t72 vss 0.07684f
C1375 vss.t71 vss 0.07684f
C1376 vss.t64 vss 0.07684f
C1377 vss.t63 vss 0.07684f
C1378 vss.t36 vss 0.07684f
C1379 vss.t34 vss 0.07684f
C1380 vss.t144 vss 0.07684f
C1381 vss.t143 vss 0.07684f
C1382 vss.t17 vss 0.07684f
C1383 vss.t15 vss 0.07684f
C1384 vss.t150 vss 0.07684f
C1385 vss.t149 vss 0.07684f
C1386 vss.t9 vss 0.07684f
C1387 vss.t7 vss 0.07684f
C1388 vss.t136 vss 0.07684f
C1389 vss.t135 vss 0.07684f
C1390 vss.t13 vss 0.07684f
C1391 vss.t11 vss 0.07684f
C1392 vss.t309 vss 0.07684f
C1393 vss.t308 vss 0.07684f
C1394 vss.t5 vss 0.07684f
C1395 vss.t3 vss 0.07684f
C1396 vss.t202 vss 0.06439f
C1397 vss.t267 vss 0.07684f
C1398 vss.t321 vss 0.06439f
C1399 vss.t156 vss 0.07684f
C1400 vss.t194 vss 0.0636f
C1401 vss.t212 vss 0.0558f
C1402 vss.t319 vss 0.05875f
C1403 vss.t320 vss 0.0558f
C1404 vss.t200 vss 0.0636f
C1405 vss.t210 vss 0.0636f
C1406 vss.t317 vss 0.05875f
C1407 vss.t318 vss 0.05875f
C1408 vss.t198 vss 0.0636f
C1409 vss.t208 vss 0.0636f
C1410 vss.t315 vss 0.05875f
C1411 vss.t316 vss 0.05875f
C1412 vss.t206 vss 0.0636f
C1413 vss.t196 vss 0.0636f
C1414 vss.t313 vss 0.05875f
C1415 vss.t314 vss 0.05875f
C1416 vss.t204 vss 0.0636f
C1417 vss.t312 vss 0.05875f
C1418 vdd.n0 vss 0.74935f
C1419 vdd.t239 vss 0.09932f
C1420 vdd.t109 vss 0.09686f
C1421 vdd.n1 vss 0.10656f
C1422 vdd.t253 vss 0.08376f
C1423 vdd.t252 vss 0.0873f
C1424 vdd.n2 vss 0.02198f
C1425 vdd.t123 vss 0.08132f
C1426 vdd.t121 vss 0.08486f
C1427 vdd.n3 vss 0.02198f
C1428 vdd.n4 vss 0.08817f
C1429 vdd.t273 vss 0.08376f
C1430 vdd.t272 vss 0.0873f
C1431 vdd.n5 vss 0.02198f
C1432 vdd.t251 vss 0.08132f
C1433 vdd.t249 vss 0.08486f
C1434 vdd.n6 vss 0.02198f
C1435 vdd.n7 vss 0.08817f
C1436 vdd.t342 vss 0.08376f
C1437 vdd.t341 vss 0.0873f
C1438 vdd.n8 vss 0.02198f
C1439 vdd.t243 vss 0.08132f
C1440 vdd.t241 vss 0.08486f
C1441 vdd.n9 vss 0.02198f
C1442 vdd.n10 vss 0.08817f
C1443 vdd.t99 vss 0.08376f
C1444 vdd.t97 vss 0.0873f
C1445 vdd.n11 vss 0.02198f
C1446 vdd.t119 vss 0.08132f
C1447 vdd.t118 vss 0.08486f
C1448 vdd.n12 vss 0.02198f
C1449 vdd.n13 vss 0.08817f
C1450 vdd.t45 vss 0.08376f
C1451 vdd.t43 vss 0.0873f
C1452 vdd.n14 vss 0.02198f
C1453 vdd.t107 vss 0.08132f
C1454 vdd.t106 vss 0.08486f
C1455 vdd.n15 vss 0.02198f
C1456 vdd.n16 vss 0.08817f
C1457 vdd.t27 vss 0.08376f
C1458 vdd.t25 vss 0.0873f
C1459 vdd.n17 vss 0.02198f
C1460 vdd.t117 vss 0.08132f
C1461 vdd.t116 vss 0.08486f
C1462 vdd.n18 vss 0.02198f
C1463 vdd.n19 vss 0.08817f
C1464 vdd.t61 vss 0.08376f
C1465 vdd.t59 vss 0.0873f
C1466 vdd.n20 vss 0.02198f
C1467 vdd.t245 vss 0.08132f
C1468 vdd.t244 vss 0.08486f
C1469 vdd.n21 vss 0.02198f
C1470 vdd.n22 vss 0.08817f
C1471 vdd.t163 vss 0.08376f
C1472 vdd.t161 vss 0.0873f
C1473 vdd.n23 vss 0.02198f
C1474 vdd.t247 vss 0.08132f
C1475 vdd.t246 vss 0.08486f
C1476 vdd.n24 vss 0.02198f
C1477 vdd.n25 vss 0.08817f
C1478 vdd.t177 vss 0.08376f
C1479 vdd.t175 vss 0.0873f
C1480 vdd.n26 vss 0.02198f
C1481 vdd.t359 vss 0.08132f
C1482 vdd.t358 vss 0.08486f
C1483 vdd.n27 vss 0.02198f
C1484 vdd.n28 vss 0.08817f
C1485 vdd.t212 vss 0.07127f
C1486 vdd.t115 vss 0.0873f
C1487 vdd.n29 vss 0.02282f
C1488 vdd.t351 vss 0.06807f
C1489 vdd.t353 vss 0.08486f
C1490 vdd.n30 vss 0.02282f
C1491 vdd.n31 vss 0.10514f
C1492 vdd.t208 vss 0.06735f
C1493 vdd.t210 vss 0.07492f
C1494 vdd.n32 vss 0.02208f
C1495 vdd.t350 vss 0.06773f
C1496 vdd.t352 vss 0.07171f
C1497 vdd.n33 vss 0.02208f
C1498 vdd.n34 vss 0.09409f
C1499 vdd.t204 vss 0.06735f
C1500 vdd.t206 vss 0.07088f
C1501 vdd.n35 vss 0.02208f
C1502 vdd.t348 vss 0.06773f
C1503 vdd.t349 vss 0.07127f
C1504 vdd.n36 vss 0.02208f
C1505 vdd.n37 vss 0.09409f
C1506 vdd.t200 vss 0.06735f
C1507 vdd.t202 vss 0.07088f
C1508 vdd.n38 vss 0.02208f
C1509 vdd.t346 vss 0.06773f
C1510 vdd.t347 vss 0.07127f
C1511 vdd.n39 vss 0.02208f
C1512 vdd.n40 vss 0.09409f
C1513 vdd.t196 vss 0.06735f
C1514 vdd.t198 vss 0.07088f
C1515 vdd.n41 vss 0.02208f
C1516 vdd.t344 vss 0.06773f
C1517 vdd.t345 vss 0.07127f
C1518 vdd.n42 vss 0.02208f
C1519 vdd.n43 vss 0.09235f
C1520 vdd.t194 vss 0.0844f
C1521 vdd.t343 vss 0.08272f
C1522 vdd.n44 vss 0.6978f
C1523 vdd.t42 vss 0.28041f
C1524 vdd.t44 vss 0.28041f
C1525 vdd.t108 vss 0.38439f
C1526 vdd.t24 vss 0.28041f
C1527 vdd.t26 vss 0.28041f
C1528 vdd.t96 vss 0.28041f
C1529 vdd.t98 vss 0.28041f
C1530 vdd.t120 vss 0.28041f
C1531 vdd.t122 vss 0.28041f
C1532 vdd.t240 vss 0.28041f
C1533 vdd.t242 vss 0.28041f
C1534 vdd.t58 vss 0.28041f
C1535 vdd.t60 vss 0.28041f
C1536 vdd.t160 vss 0.28041f
C1537 vdd.t162 vss 0.28041f
C1538 vdd.t248 vss 0.28041f
C1539 vdd.t250 vss 0.28041f
C1540 vdd.t193 vss 0.32254f
C1541 vdd.t195 vss 0.28041f
C1542 vdd.t197 vss 0.28041f
C1543 vdd.t199 vss 0.28041f
C1544 vdd.t201 vss 0.28041f
C1545 vdd.t203 vss 0.28041f
C1546 vdd.t205 vss 0.28041f
C1547 vdd.t207 vss 0.28041f
C1548 vdd.t209 vss 0.28041f
C1549 vdd.t211 vss 0.28041f
C1550 vdd.t114 vss 0.28041f
C1551 vdd.t174 vss 0.28041f
C1552 vdd.t176 vss 0.28041f
C1553 vdd.n45 vss 4.3789f
C1554 vdd.n46 vss 0.74935f
C1555 vdd.t181 vss 0.09932f
C1556 vdd.t184 vss 0.09932f
C1557 vdd.n47 vss 0.10656f
C1558 vdd.t169 vss 0.08376f
C1559 vdd.t167 vss 0.0873f
C1560 vdd.n48 vss 0.02198f
C1561 vdd.t238 vss 0.08376f
C1562 vdd.t237 vss 0.0873f
C1563 vdd.n49 vss 0.02198f
C1564 vdd.n50 vss 0.08817f
C1565 vdd.t155 vss 0.08376f
C1566 vdd.t153 vss 0.0873f
C1567 vdd.n51 vss 0.02198f
C1568 vdd.t357 vss 0.08376f
C1569 vdd.t356 vss 0.0873f
C1570 vdd.n52 vss 0.02198f
C1571 vdd.n53 vss 0.08817f
C1572 vdd.t141 vss 0.08376f
C1573 vdd.t139 vss 0.0873f
C1574 vdd.n54 vss 0.02198f
C1575 vdd.t190 vss 0.08376f
C1576 vdd.t189 vss 0.0873f
C1577 vdd.n55 vss 0.02198f
C1578 vdd.n56 vss 0.08817f
C1579 vdd.t149 vss 0.08376f
C1580 vdd.t147 vss 0.0873f
C1581 vdd.n57 vss 0.02198f
C1582 vdd.t271 vss 0.08376f
C1583 vdd.t270 vss 0.0873f
C1584 vdd.n58 vss 0.02198f
C1585 vdd.n59 vss 0.08817f
C1586 vdd.t133 vss 0.08376f
C1587 vdd.t131 vss 0.0873f
C1588 vdd.n60 vss 0.02198f
C1589 vdd.t340 vss 0.08376f
C1590 vdd.t339 vss 0.0873f
C1591 vdd.n61 vss 0.02198f
C1592 vdd.n62 vss 0.08817f
C1593 vdd.t93 vss 0.08376f
C1594 vdd.t91 vss 0.0873f
C1595 vdd.n63 vss 0.02198f
C1596 vdd.t95 vss 0.08376f
C1597 vdd.t94 vss 0.0873f
C1598 vdd.n64 vss 0.02198f
C1599 vdd.n65 vss 0.08817f
C1600 vdd.t188 vss 0.08376f
C1601 vdd.t186 vss 0.0873f
C1602 vdd.n66 vss 0.02198f
C1603 vdd.t236 vss 0.08376f
C1604 vdd.t235 vss 0.0873f
C1605 vdd.n67 vss 0.02198f
C1606 vdd.n68 vss 0.08817f
C1607 vdd.t49 vss 0.08376f
C1608 vdd.t47 vss 0.0873f
C1609 vdd.n69 vss 0.02198f
C1610 vdd.t355 vss 0.08376f
C1611 vdd.t354 vss 0.0873f
C1612 vdd.n70 vss 0.02198f
C1613 vdd.n71 vss 0.08817f
C1614 vdd.t31 vss 0.08376f
C1615 vdd.t29 vss 0.0873f
C1616 vdd.n72 vss 0.02198f
C1617 vdd.t269 vss 0.08376f
C1618 vdd.t268 vss 0.0873f
C1619 vdd.n73 vss 0.02198f
C1620 vdd.n74 vss 0.08817f
C1621 vdd.t307 vss 0.07126f
C1622 vdd.t63 vss 0.0873f
C1623 vdd.n75 vss 0.02282f
C1624 vdd.t293 vss 0.07126f
C1625 vdd.t338 vss 0.0873f
C1626 vdd.n76 vss 0.02282f
C1627 vdd.n77 vss 0.10514f
C1628 vdd.t305 vss 0.06734f
C1629 vdd.t306 vss 0.07491f
C1630 vdd.n78 vss 0.02208f
C1631 vdd.t289 vss 0.07091f
C1632 vdd.t291 vss 0.07491f
C1633 vdd.n79 vss 0.02208f
C1634 vdd.n80 vss 0.09409f
C1635 vdd.t303 vss 0.06734f
C1636 vdd.t304 vss 0.07088f
C1637 vdd.n81 vss 0.02208f
C1638 vdd.t285 vss 0.07091f
C1639 vdd.t287 vss 0.07444f
C1640 vdd.n82 vss 0.02208f
C1641 vdd.n83 vss 0.09409f
C1642 vdd.t301 vss 0.06734f
C1643 vdd.t302 vss 0.07088f
C1644 vdd.n84 vss 0.02208f
C1645 vdd.t281 vss 0.07091f
C1646 vdd.t283 vss 0.07444f
C1647 vdd.n85 vss 0.02208f
C1648 vdd.n86 vss 0.09409f
C1649 vdd.t299 vss 0.06734f
C1650 vdd.t300 vss 0.07088f
C1651 vdd.n87 vss 0.02208f
C1652 vdd.t277 vss 0.07091f
C1653 vdd.t279 vss 0.07444f
C1654 vdd.n88 vss 0.02208f
C1655 vdd.n89 vss 0.09235f
C1656 vdd.t298 vss 0.08439f
C1657 vdd.t275 vss 0.08589f
C1658 vdd.n90 vss 0.6978f
C1659 vdd.t90 vss 0.28041f
C1660 vdd.t92 vss 0.28041f
C1661 vdd.t180 vss 0.38439f
C1662 vdd.t138 vss 0.28041f
C1663 vdd.t140 vss 0.28041f
C1664 vdd.t185 vss 0.28041f
C1665 vdd.t187 vss 0.28041f
C1666 vdd.t166 vss 0.28041f
C1667 vdd.t168 vss 0.28041f
C1668 vdd.t28 vss 0.28041f
C1669 vdd.t30 vss 0.28041f
C1670 vdd.t146 vss 0.28041f
C1671 vdd.t148 vss 0.28041f
C1672 vdd.t274 vss 0.32254f
C1673 vdd.t276 vss 0.28041f
C1674 vdd.t278 vss 0.28041f
C1675 vdd.t280 vss 0.28041f
C1676 vdd.t282 vss 0.28041f
C1677 vdd.t284 vss 0.28041f
C1678 vdd.t286 vss 0.28041f
C1679 vdd.t288 vss 0.28041f
C1680 vdd.t290 vss 0.28041f
C1681 vdd.t292 vss 0.28041f
C1682 vdd.t62 vss 0.28041f
C1683 vdd.t130 vss 0.28041f
C1684 vdd.t132 vss 0.28041f
C1685 vdd.t46 vss 0.28041f
C1686 vdd.t48 vss 0.28041f
C1687 vdd.t152 vss 0.28041f
C1688 vdd.t154 vss 0.28041f
C1689 vdd.n91 vss 0.18607f
C1690 vdd.n92 vss 0.74935f
C1691 vdd.t33 vss 0.09932f
C1692 vdd.t297 vss 0.09932f
C1693 vdd.n93 vss 0.10656f
C1694 vdd.t15 vss 0.08376f
C1695 vdd.t13 vss 0.0873f
C1696 vdd.n94 vss 0.02198f
C1697 vdd.t267 vss 0.08376f
C1698 vdd.t266 vss 0.0873f
C1699 vdd.n95 vss 0.02198f
C1700 vdd.n96 vss 0.08817f
C1701 vdd.t7 vss 0.08376f
C1702 vdd.t5 vss 0.0873f
C1703 vdd.n97 vss 0.02198f
C1704 vdd.t192 vss 0.08376f
C1705 vdd.t191 vss 0.0873f
C1706 vdd.n98 vss 0.02198f
C1707 vdd.n99 vss 0.08817f
C1708 vdd.t11 vss 0.08376f
C1709 vdd.t9 vss 0.0873f
C1710 vdd.n100 vss 0.02198f
C1711 vdd.t214 vss 0.08376f
C1712 vdd.t213 vss 0.0873f
C1713 vdd.n101 vss 0.02198f
C1714 vdd.n102 vss 0.08817f
C1715 vdd.t3 vss 0.08376f
C1716 vdd.t1 vss 0.0873f
C1717 vdd.n103 vss 0.02198f
C1718 vdd.t113 vss 0.08376f
C1719 vdd.t112 vss 0.0873f
C1720 vdd.n104 vss 0.02198f
C1721 vdd.n105 vss 0.08817f
C1722 vdd.t179 vss 0.08376f
C1723 vdd.t178 vss 0.0873f
C1724 vdd.n106 vss 0.02198f
C1725 vdd.t41 vss 0.08376f
C1726 vdd.t39 vss 0.0873f
C1727 vdd.n107 vss 0.02198f
C1728 vdd.n108 vss 0.08817f
C1729 vdd.t165 vss 0.08376f
C1730 vdd.t164 vss 0.0873f
C1731 vdd.n109 vss 0.02198f
C1732 vdd.t23 vss 0.08376f
C1733 vdd.t21 vss 0.0873f
C1734 vdd.n110 vss 0.02198f
C1735 vdd.n111 vss 0.08817f
C1736 vdd.t151 vss 0.08376f
C1737 vdd.t150 vss 0.0873f
C1738 vdd.n112 vss 0.02198f
C1739 vdd.t57 vss 0.08376f
C1740 vdd.t55 vss 0.0873f
C1741 vdd.n113 vss 0.02198f
C1742 vdd.n114 vss 0.08817f
C1743 vdd.t137 vss 0.08376f
C1744 vdd.t135 vss 0.0873f
C1745 vdd.n115 vss 0.02198f
C1746 vdd.t159 vss 0.08376f
C1747 vdd.t158 vss 0.0873f
C1748 vdd.n116 vss 0.02198f
C1749 vdd.n117 vss 0.08817f
C1750 vdd.t145 vss 0.08376f
C1751 vdd.t143 vss 0.0873f
C1752 vdd.n118 vss 0.02198f
C1753 vdd.t173 vss 0.08376f
C1754 vdd.t172 vss 0.0873f
C1755 vdd.n119 vss 0.02198f
C1756 vdd.n120 vss 0.08817f
C1757 vdd.t263 vss 0.07126f
C1758 vdd.t129 vss 0.0873f
C1759 vdd.n121 vss 0.02282f
C1760 vdd.t234 vss 0.07126f
C1761 vdd.t111 vss 0.0873f
C1762 vdd.n122 vss 0.02282f
C1763 vdd.n123 vss 0.10514f
C1764 vdd.t261 vss 0.06734f
C1765 vdd.t262 vss 0.07491f
C1766 vdd.n124 vss 0.02208f
C1767 vdd.t230 vss 0.07091f
C1768 vdd.t232 vss 0.07491f
C1769 vdd.n125 vss 0.02208f
C1770 vdd.n126 vss 0.09409f
C1771 vdd.t259 vss 0.06734f
C1772 vdd.t260 vss 0.07088f
C1773 vdd.n127 vss 0.02208f
C1774 vdd.t226 vss 0.07091f
C1775 vdd.t228 vss 0.07444f
C1776 vdd.n128 vss 0.02208f
C1777 vdd.n129 vss 0.09409f
C1778 vdd.t257 vss 0.06734f
C1779 vdd.t258 vss 0.07088f
C1780 vdd.n130 vss 0.02208f
C1781 vdd.t222 vss 0.07091f
C1782 vdd.t224 vss 0.07444f
C1783 vdd.n131 vss 0.02208f
C1784 vdd.n132 vss 0.09409f
C1785 vdd.t255 vss 0.06734f
C1786 vdd.t256 vss 0.07088f
C1787 vdd.n133 vss 0.02208f
C1788 vdd.t218 vss 0.07091f
C1789 vdd.t220 vss 0.07444f
C1790 vdd.n134 vss 0.02208f
C1791 vdd.n135 vss 0.09235f
C1792 vdd.t254 vss 0.08439f
C1793 vdd.t216 vss 0.08589f
C1794 vdd.n136 vss 0.6978f
C1795 vdd.t20 vss 0.28041f
C1796 vdd.t22 vss 0.28041f
C1797 vdd.t38 vss 0.28041f
C1798 vdd.t40 vss 0.28041f
C1799 vdd.t54 vss 0.28041f
C1800 vdd.t56 vss 0.28041f
C1801 vdd.t110 vss 0.28041f
C1802 vdd.t0 vss 0.28041f
C1803 vdd.t2 vss 0.28041f
C1804 vdd.t134 vss 0.28041f
C1805 vdd.t136 vss 0.28041f
C1806 vdd.t142 vss 0.28041f
C1807 vdd.t144 vss 0.28041f
C1808 vdd.t4 vss 0.28041f
C1809 vdd.t6 vss 0.28041f
C1810 vdd.t8 vss 0.28041f
C1811 vdd.t10 vss 0.28041f
C1812 vdd.t215 vss 0.32254f
C1813 vdd.t217 vss 0.28041f
C1814 vdd.t219 vss 0.28041f
C1815 vdd.t221 vss 0.28041f
C1816 vdd.t223 vss 0.28041f
C1817 vdd.t225 vss 0.28041f
C1818 vdd.t227 vss 0.28041f
C1819 vdd.t229 vss 0.28041f
C1820 vdd.t231 vss 0.28041f
C1821 vdd.t233 vss 0.28041f
C1822 vdd.t12 vss 0.28041f
C1823 vdd.t14 vss 0.28041f
C1824 vdd.t32 vss 0.38439f
C1825 vdd.n137 vss 0.25941f
C1826 vdd.n138 vss 0.77584f
C1827 vdd.t156 vss 0.09681f
C1828 vdd.t79 vss 0.09932f
C1829 vdd.n139 vss 0.10656f
C1830 vdd.t170 vss 0.08128f
C1831 vdd.t157 vss 0.08482f
C1832 vdd.n140 vss 0.02198f
C1833 vdd.t77 vss 0.08376f
C1834 vdd.t75 vss 0.0873f
C1835 vdd.n141 vss 0.02198f
C1836 vdd.n142 vss 0.08817f
C1837 vdd.t182 vss 0.08128f
C1838 vdd.t171 vss 0.08482f
C1839 vdd.n143 vss 0.02198f
C1840 vdd.t105 vss 0.08376f
C1841 vdd.t103 vss 0.0873f
C1842 vdd.n144 vss 0.02198f
C1843 vdd.n145 vss 0.08817f
C1844 vdd.t88 vss 0.08128f
C1845 vdd.t183 vss 0.08482f
C1846 vdd.n146 vss 0.02198f
C1847 vdd.t128 vss 0.08376f
C1848 vdd.t127 vss 0.0873f
C1849 vdd.n147 vss 0.02198f
C1850 vdd.n148 vss 0.08817f
C1851 vdd.t84 vss 0.08128f
C1852 vdd.t89 vss 0.08482f
C1853 vdd.n149 vss 0.02198f
C1854 vdd.t73 vss 0.08376f
C1855 vdd.t71 vss 0.0873f
C1856 vdd.n150 vss 0.02198f
C1857 vdd.n151 vss 0.08817f
C1858 vdd.t81 vss 0.08128f
C1859 vdd.t86 vss 0.08482f
C1860 vdd.n152 vss 0.02198f
C1861 vdd.t296 vss 0.08376f
C1862 vdd.t295 vss 0.0873f
C1863 vdd.n153 vss 0.02198f
C1864 vdd.n154 vss 0.08817f
C1865 vdd.t65 vss 0.08128f
C1866 vdd.t83 vss 0.08482f
C1867 vdd.n155 vss 0.02198f
C1868 vdd.t265 vss 0.08376f
C1869 vdd.t264 vss 0.0873f
C1870 vdd.n156 vss 0.02198f
C1871 vdd.n157 vss 0.08817f
C1872 vdd.t35 vss 0.08128f
C1873 vdd.t67 vss 0.08482f
C1874 vdd.n158 vss 0.02198f
C1875 vdd.t101 vss 0.08376f
C1876 vdd.t100 vss 0.0873f
C1877 vdd.n159 vss 0.02198f
C1878 vdd.n160 vss 0.08817f
C1879 vdd.t17 vss 0.08128f
C1880 vdd.t37 vss 0.08482f
C1881 vdd.n161 vss 0.02198f
C1882 vdd.t125 vss 0.08376f
C1883 vdd.t124 vss 0.0873f
C1884 vdd.n162 vss 0.02198f
C1885 vdd.n163 vss 0.08817f
C1886 vdd.t51 vss 0.08128f
C1887 vdd.t19 vss 0.08482f
C1888 vdd.n164 vss 0.02198f
C1889 vdd.t69 vss 0.08376f
C1890 vdd.t68 vss 0.0873f
C1891 vdd.n165 vss 0.02198f
C1892 vdd.n166 vss 0.08817f
C1893 vdd.t337 vss 0.06758f
C1894 vdd.t53 vss 0.08482f
C1895 vdd.n167 vss 0.02282f
C1896 vdd.t325 vss 0.07126f
C1897 vdd.t294 vss 0.0873f
C1898 vdd.n168 vss 0.02282f
C1899 vdd.n169 vss 0.10514f
C1900 vdd.t335 vss 0.06389f
C1901 vdd.t336 vss 0.07122f
C1902 vdd.n170 vss 0.02208f
C1903 vdd.t323 vss 0.07091f
C1904 vdd.t327 vss 0.07491f
C1905 vdd.n171 vss 0.02208f
C1906 vdd.n172 vss 0.09409f
C1907 vdd.t333 vss 0.06389f
C1908 vdd.t334 vss 0.06743f
C1909 vdd.n173 vss 0.02208f
C1910 vdd.t319 vss 0.07091f
C1911 vdd.t321 vss 0.07444f
C1912 vdd.n174 vss 0.02208f
C1913 vdd.n175 vss 0.09409f
C1914 vdd.t331 vss 0.06389f
C1915 vdd.t332 vss 0.06743f
C1916 vdd.n176 vss 0.02208f
C1917 vdd.t315 vss 0.07091f
C1918 vdd.t317 vss 0.07444f
C1919 vdd.n177 vss 0.02208f
C1920 vdd.n178 vss 0.09409f
C1921 vdd.t329 vss 0.06389f
C1922 vdd.t330 vss 0.06743f
C1923 vdd.n179 vss 0.02208f
C1924 vdd.t311 vss 0.07091f
C1925 vdd.t313 vss 0.07444f
C1926 vdd.n180 vss 0.02208f
C1927 vdd.n181 vss 0.09235f
C1928 vdd.t328 vss 0.08082f
C1929 vdd.t309 vss 0.08589f
C1930 vdd.n182 vss 0.6978f
C1931 vdd.t18 vss 0.28041f
C1932 vdd.t50 vss 0.28041f
C1933 vdd.t70 vss 0.28041f
C1934 vdd.t72 vss 0.28041f
C1935 vdd.t74 vss 0.28041f
C1936 vdd.t76 vss 0.28041f
C1937 vdd.t78 vss 0.38439f
C1938 vdd.t66 vss 0.28041f
C1939 vdd.t34 vss 0.28041f
C1940 vdd.t102 vss 0.28041f
C1941 vdd.t104 vss 0.28041f
C1942 vdd.t36 vss 0.28041f
C1943 vdd.t16 vss 0.28041f
C1944 vdd.t126 vss 0.28041f
C1945 vdd.t87 vss 0.28041f
C1946 vdd.t82 vss 0.28041f
C1947 vdd.t64 vss 0.28041f
C1948 vdd.t52 vss 0.28041f
C1949 vdd.t85 vss 0.28041f
C1950 vdd.t80 vss 0.28041f
C1951 vdd.t308 vss 0.32254f
C1952 vdd.t310 vss 0.28041f
C1953 vdd.t312 vss 0.28041f
C1954 vdd.t314 vss 0.28041f
C1955 vdd.t316 vss 0.28041f
C1956 vdd.t318 vss 0.28041f
C1957 vdd.t320 vss 0.28041f
C1958 vdd.t322 vss 0.28041f
C1959 vdd.t326 vss 0.28041f
C1960 vdd.t324 vss 0.28041f
C1961 vout.t1 vss 0.46491f
C1962 vout.t0 vss 0.58874f
C1963 vout.n0 vss 1.46541f
C1964 dac_code[7].n0 vss 0.12364f
C1965 dac_code[7].n1 vss 0.13955f
C1966 dac_code[7].n2 vss 0.13955f
C1967 dac_code[7].n3 vss 0.13955f
C1968 dac_code[7].n4 vss 0.06269f
C1969 dac_code[7].n5 vss 0.11297f
C1970 dac_code[7].n6 vss 0.07565f
C1971 dac_code[7].n7 vss 0.13955f
C1972 dac_code[7].n8 vss 0.13955f
C1973 dac_code[7].n9 vss 0.13955f
C1974 dac_code[7].n10 vss 1.95589f
C1975 dac_code[6].n0 vss 0.14143f
C1976 dac_code[6].n1 vss 0.07805f
C1977 dac_code[6].n2 vss 0.0859f
C1978 dac_code[6].n3 vss 0.07805f
C1979 dac_code[6].n4 vss 0.0859f
C1980 dac_code[6].n5 vss 0.07805f
C1981 dac_code[6].n6 vss 0.08315f
C1982 dac_code[6].n7 vss 0.06609f
C1983 dac_code[6].n8 vss 0.1191f
C1984 dac_code[6].n9 vss 0.08944f
C1985 dac_code[6].n10 vss 0.07805f
C1986 dac_code[6].n11 vss 0.07783f
C1987 dac_code[6].n12 vss 0.07805f
C1988 dac_code[6].n13 vss 0.0859f
C1989 dac_code[6].n14 vss 0.07805f
C1990 dac_code[6].n15 vss 0.0859f
C1991 dac_code[6].n16 vss 0.04626f
C1992 dac_code[6].n17 vss 0.0859f
C1993 dac_code[6].n18 vss 1.94951f
C1994 dac_code[5].n0 vss 0.13034f
C1995 dac_code[5].n1 vss 0.14712f
C1996 dac_code[5].n2 vss 0.14712f
C1997 dac_code[5].n3 vss 0.14712f
C1998 dac_code[5].n4 vss 0.06609f
C1999 dac_code[5].n5 vss 0.11909f
C2000 dac_code[5].n6 vss 0.07975f
C2001 dac_code[5].n7 vss 0.14712f
C2002 dac_code[5].n8 vss 0.14712f
C2003 dac_code[5].n9 vss 0.14712f
C2004 dac_code[5].n10 vss 2.0619f
C2005 dac_code[4].n0 vss 0.14141f
C2006 dac_code[4].n1 vss 0.07804f
C2007 dac_code[4].n2 vss 0.08589f
C2008 dac_code[4].n3 vss 0.07804f
C2009 dac_code[4].n4 vss 0.08589f
C2010 dac_code[4].n5 vss 0.07804f
C2011 dac_code[4].n6 vss 0.08314f
C2012 dac_code[4].n7 vss 0.06609f
C2013 dac_code[4].n8 vss 0.11909f
C2014 dac_code[4].n9 vss 0.08943f
C2015 dac_code[4].n10 vss 0.07804f
C2016 dac_code[4].n11 vss 0.07782f
C2017 dac_code[4].n12 vss 0.07804f
C2018 dac_code[4].n13 vss 0.08589f
C2019 dac_code[4].n14 vss 0.07804f
C2020 dac_code[4].n15 vss 0.08589f
C2021 dac_code[4].n16 vss 0.04626f
C2022 dac_code[4].n17 vss 0.08589f
C2023 dac_code[4].n18 vss 1.94931f
C2024 dac_code[3].n0 vss 0.13034f
C2025 dac_code[3].n1 vss 0.14712f
C2026 dac_code[3].n2 vss 0.14712f
C2027 dac_code[3].n3 vss 0.14712f
C2028 dac_code[3].n4 vss 0.06609f
C2029 dac_code[3].n5 vss 0.11909f
C2030 dac_code[3].n6 vss 0.07975f
C2031 dac_code[3].n7 vss 0.14712f
C2032 dac_code[3].n8 vss 0.14712f
C2033 dac_code[3].n9 vss 0.14712f
C2034 dac_code[3].n10 vss 2.0619f
C2035 dac_code[2].n0 vss 0.14141f
C2036 dac_code[2].n1 vss 0.07804f
C2037 dac_code[2].n2 vss 0.08589f
C2038 dac_code[2].n3 vss 0.07804f
C2039 dac_code[2].n4 vss 0.08589f
C2040 dac_code[2].n5 vss 0.07804f
C2041 dac_code[2].n6 vss 0.08314f
C2042 dac_code[2].n7 vss 0.06609f
C2043 dac_code[2].n8 vss 0.11909f
C2044 dac_code[2].n9 vss 0.08943f
C2045 dac_code[2].n10 vss 0.07804f
C2046 dac_code[2].n11 vss 0.07782f
C2047 dac_code[2].n12 vss 0.07804f
C2048 dac_code[2].n13 vss 0.08589f
C2049 dac_code[2].n14 vss 0.07804f
C2050 dac_code[2].n15 vss 0.08589f
C2051 dac_code[2].n16 vss 0.04626f
C2052 dac_code[2].n17 vss 0.08589f
C2053 dac_code[2].n18 vss 1.94931f
C2054 dac_code[1].n0 vss 0.13034f
C2055 dac_code[1].n1 vss 0.14712f
C2056 dac_code[1].n2 vss 0.14712f
C2057 dac_code[1].n3 vss 0.14712f
C2058 dac_code[1].n4 vss 0.06609f
C2059 dac_code[1].n5 vss 0.11909f
C2060 dac_code[1].n6 vss 0.07975f
C2061 dac_code[1].n7 vss 0.14712f
C2062 dac_code[1].n8 vss 0.14712f
C2063 dac_code[1].n9 vss 0.14712f
C2064 dac_code[1].n10 vss 2.0619f
C2065 dac_code[0].n0 vss 0.13303f
C2066 dac_code[0].n1 vss 0.07341f
C2067 dac_code[0].n2 vss 0.08079f
C2068 dac_code[0].n3 vss 0.07341f
C2069 dac_code[0].n4 vss 0.08079f
C2070 dac_code[0].n5 vss 0.07341f
C2071 dac_code[0].n6 vss 0.07821f
C2072 dac_code[0].n7 vss 0.06217f
C2073 dac_code[0].n8 vss 0.11203f
C2074 dac_code[0].n9 vss 0.08412f
C2075 dac_code[0].n10 vss 0.07341f
C2076 dac_code[0].n11 vss 0.0732f
C2077 dac_code[0].n12 vss 0.07341f
C2078 dac_code[0].n13 vss 0.08079f
C2079 dac_code[0].n14 vss 0.07341f
C2080 dac_code[0].n15 vss 0.08079f
C2081 dac_code[0].n16 vss 0.04352f
C2082 dac_code[0].n17 vss 0.08079f
C2083 dac_code[0].n18 vss 1.83369f
.ends
